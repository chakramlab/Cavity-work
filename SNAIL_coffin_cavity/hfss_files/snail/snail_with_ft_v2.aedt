# Ansys Electronics Desktop project, version 2023.2
project variables:
  $jj_length = 30um
  $chip_length = 34.75mm
  $chip_width = 6.7mm
  $chip_thickness = 0.43mm
  $chip_delta_x = 0.565mm
  $chip_delta_y = 2.25mm
  $chip_delta_z = $chip_thickness
  $chip_padding = 0.4mm
materials:
  vacuum: permittivity=1
  silicon - tensor: permittivity{Symmetric Component1=9.27 Component2=0 Component3=0 Component4=0 Component5=9.27 Component6=0 Component7=0 Component8=0 Component9=11.35}

design HFSSDesign1 (HFSS, Eigenmode, model units mm)
geometry:
  BASEMETAL_3122, BASEMETAL_3123, FT_3181 = imported_body(C:/Users/ajb/AppData/Local/Temp/7935362417184941136..x_t)
  pad_1 = object_from(?.face(#88516))
  BASEMETAL_3123.delete()
  pad_2 = object_from(?.face(#87396))
  BASEMETAL_3122.delete()
  ft = object_from(?.face(#139712))
  FT_3181.delete()
  [pad_1, pad_2, ft].scale(0.001, 0.001, 0.001)
  [pad_1, pad_2, ft].move(0mm, 0mm, -0.0001mm)
  coordinate_system RelativeCS1 = origin=(-20.875mm, -39.05mm, 0mm) x=(1mm, 0mm, 0mm) y=(0mm, 1mm, 0mm)
  ft.move(10um, 0mm, 0mm) in RelativeCS1
  jj = rectangle(corner=(-$jj_length/2, -$jj_length/2, 0mm), x_size=$jj_length, y_size=$jj_length) in RelativeCS1
  substrate [silicon - tensor] = box(corner=(-$chip_delta_x, -$chip_delta_y, -$chip_delta_z), size=($chip_length, $chip_width, $chip_thickness)) in RelativeCS1
  [pad_1, pad_2, ft, jj, substrate].move(21.44mm, 41.3mm, 0.43mm)
  coordinate_system RelativeCSJJ = origin=(0.565mm, 2.25mm, 0.43mm) x=(1mm, 0mm, 0mm) y=(0mm, 1mm, 0mm)
  lead_1 = rectangle(corner=(-$jj_length/2, -100um, 0mm), x_size=$jj_length, y_size=100um - $jj_length/2) in RelativeCSJJ
  lead_2 = rectangle(corner=(-$jj_length/2, $jj_length/2, 0mm), x_size=$jj_length, y_size=100um - $jj_length/2) in RelativeCSJJ
  pad_1.unite(lead_1)
  pad_2.unite(lead_2)
  chip_padding_2 = box(corner=(0mm, $chip_width, 0), size=($chip_length, $chip_padding, $chip_thickness))
  chip_padding_1 = box(corner=(0mm, -$chip_padding, 0), size=($chip_length, $chip_padding, $chip_thickness))
  substrate.unite(chip_padding_2, chip_padding_1)
  [pad_1, pad_2, ft, jj, substrate].move(0mm, 0.4mm, 0mm)
  Rectangle1 = rectangle(corner=(0.616mm, 2.6mm, $chip_thickness), x_size=-0.026mm, y_size=0.01mm)
  Rectangle2 = rectangle(corner=(0.616mm, 2.69mm, $chip_thickness), x_size=-0.026mm, y_size=0.01mm)
  ft_coupler = rectangle(corner=(0.59mm, 2.61mm, $chip_thickness), x_size=3um, y_size=0.08mm)
  Rectangle4 = rectangle(corner=(0.593mm, 2.61mm, 0.43mm), x_size=0.009mm, y_size=0.004mm)
  Rectangle5 = rectangle(corner=(0.593mm, 2.69mm, 0.43mm), x_size=0.009mm, y_size=-0.004mm)
  ft.subtract(Rectangle4, Rectangle5)
  ft.unite(Rectangle1, Rectangle2)
  Rectangle6 = rectangle(corner=(0.59mm, 2.61mm, $chip_thickness), x_size=3um, y_size=0.08mm)
  ft.subtract(Rectangle6)
setups:
  Setup1: HfssEigen MinimumFrequency=1GHz NumModes=5 MaxDeltaFreq=1 ConvergeOnRealFreq=true MaximumPasses=7 MinimumPasses=1 MinimumConvergedPasses=1 PercentRefinement=30 BasisOrder=1
source amplitudes:
  #-10:1: 1 0deg
  #-10:2..#-10:5: 0 0deg
