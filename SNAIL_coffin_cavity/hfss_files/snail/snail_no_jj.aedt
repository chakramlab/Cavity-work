# Ansys Electronics Desktop project, version 2023.2
materials:
  vacuum: permittivity=1

design HFSSDesign1 (HFSS, HFSS Terminal Network, model units mm)
geometry:
  BASEMETAL_3122, BASEMETAL_3123, FT_3181 = imported_body(C:/Users/ajb/AppData/Local/Temp/7935362417184941136..x_t)
  pad_1 = object_from(?.face(#88516))
  BASEMETAL_3123.delete()
  pad_2 = object_from(?.face(#87396))
  BASEMETAL_3122.delete()
  ft = object_from(?.face(#139712))
  FT_3181.delete()
  [pad_1, pad_2, ft].scale(0.001, 0.001, 0.001)
  [pad_1, pad_2, ft].move(0mm, 0mm, -0.0001mm)
  coordinate_system RelativeCS1 = origin=(-20.875mm, -39.05mm, 0mm) x=(1mm, 0mm, 0mm) y=(0mm, 1mm, 0mm)
