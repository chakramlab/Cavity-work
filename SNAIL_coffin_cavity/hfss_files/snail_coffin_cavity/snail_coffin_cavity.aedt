# Ansys Electronics Desktop project, version 2023.2
project variables:
  $cavity_x = 32mm
  $cavity_y = 9mm
  $cavity_z = 32mm
  $chip_length = 34.75mm
  $chip_width = 7.5mm
  $chip_thickness = 0.43mm
  $chip_delta_x_neg = 2.25mm
  $chip_delta_x_pos = 4.45mm
  $chip_delta_y_neg = 0mm
  $chip_delta_y_pos = 0.565mm
  $theta = 85deg
  $flux_loop_length = 8.105mm
  $flux_loop_width = 1mm
  $flux_loop_padding = 0.43mm
  $sma_port_length = 8.75mm
  $sma_port_diameter = 2.946mm
  $seam_width = 1.2mm
  $padding = 5mm
  $flux_delta_x_neg = 0.05mm
  $flux_delta_x_pos = 0.95mm
  $chip_padding = 0.4mm
  $sma_pin_length = 5mm
  $sma_pin_radius = 0.635mm
materials:
  vacuum: permittivity=1
  cryo_copper: permittivity=1 permeability=1 conductivity=5800000000

design EM_Cavity (HFSS, Eigenmode, model units mm)
geometry:
  Solid1, Solid1_1 = imported_body(inventor_files\snail_coffin_cavity.stp)
  cavity [vacuum] = box(corner=(-39.185mm, -39.185mm, -21mm), size=(60.185mm, 52.435mm, 42mm))
  cavity.subtract(Solid1, Solid1_1)
  sma_pin_1 = cylinder(axis=Y, base_centre=(0mm, $cavity_y/2 + $sma_port_length - $sma_pin_length, -$cavity_z/4), radius=$sma_pin_radius, height=$sma_pin_length)
  sma_pin_2 = cylinder(axis=Y, base_centre=(0mm, $cavity_y/2 + $sma_port_length - $sma_pin_length, $cavity_z/4), radius=$sma_pin_radius, height=$sma_pin_length)
  cavity.subtract(sma_pin_1, sma_pin_2)
  cavity.rotate(axis=Z, angle=90deg)
boundaries and excitations:
  sma: Impedance Faces=cavity.face(at (-13.25, 0, -8), at (-13.25, 0, 8)) Resistance=50 Reactance=0
  cryo_copper: Finite Conductivity Faces=cavity.face(at (21.0932, -0.741211, 0), at (0, 0, 16), at (3.91421, -15.4142, 0), at (0, -16, 0), at (-3.91421, -15.4142, 0), at (-4.5, 0, 0), at (-3.91421, 15.4142, 0), at (0, 16, 0), at (3.91421, 15.4142, 0), at (4.5, 0, 0), at (19.4888, 3.16348, 0), at (8.03554, 0.401183, 0.215)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) UseMaterial Material=cryo_copper IsInternal
setups:
  EM_Cavity: HfssEigen MinimumFrequency=2GHz NumModes=10 MaxDeltaFreq=0.05 ConvergeOnRealFreq=true MaximumPasses=20 MinimumPasses=2 MinimumConvergedPasses=2 PercentRefinement=30 BasisOrder=-1
source amplitudes:
  #-10:1: 1 0deg
  #-10:2..#-10:10: 0 0deg

design EM_Snail (HFSS, Eigenmode, model units mm)
geometry:
  pad_1, pad_2, ft, jj, substrate = imported_body(c:\Users\epm114\Documents\GitHub\Cavity work\SNAIL_coffin_cavity/hfss_files/snail/snail.sab)
  [pad_1, pad_2, ft, jj, substrate].move(-0.565mm, -2.65mm, -0.43mm)
  [pad_1, pad_2, ft, jj, substrate].rotate(axis=Z, angle=-5deg)
  vacuum_box [vacuum] = box(corner=(0mm, 0mm, -2.5mm), size=($chip_length, $chip_width, $chip_thickness + 5mm))
  vacuum_box.move(-0.565mm, -2.65mm, -0.43mm)
  vacuum_box.rotate(axis=Z, angle=-5deg)
  group snail = pad_1, pad_2, ft, jj, substrate
boundaries and excitations:
  pads: Perfect E Objects=[pad_1, pad_2]
  ft: Perfect E Objects=ft
  jj: Lumped RLC Objects=jj CurrentLine{(-0.0013073361, -0.01494292, 0) -> (0.0013073361, 0.01494292, 0)} RLC_Type=Parallel Inductance=5.9e-09H
mesh:
  substrate: LengthBased Objects=substrate MaxLength=2mm
  pads: LengthBased Objects=[pad_1, pad_2] MaxLength=100um
  jj: LengthBased Objects=jj MaxLength=10um
  ft: LengthBased Objects=ft MaxLength=20um
  ft_curvilinear: Curvilinear Objects=ft Apply
  ft_surf_approx: SurfApproxBased Objects=ft CurvedSurfaceApproxChoice=UseSlider SliderMeshSettings=9
  ft_suface_priority: SurfaceRepPriority Objects=ft SurfaceRepPriority=1
setups:
  EM_Snail: HfssEigen MinimumFrequency=2GHz NumModes=5 MaxDeltaFreq=0.1 ConvergeOnRealFreq=true MaximumPasses=20 MinimumPasses=2 MinimumConvergedPasses=2 PercentRefinement=30 BasisOrder=-1
source amplitudes:
  #-10:1: 1 0deg
  #-10:2..#-10:5: 0 0deg
