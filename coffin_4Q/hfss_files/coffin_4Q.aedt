# Ansys Electronics Desktop project, version 2023.2
project variables:
  $cav_L = 60mm
  $cav_W = 8mm
  $cav_H = 21.86mm
  $cav_r = 2mm
  $wall_x = 10mm
  $wall_z = 5mm
  $wall_back = 10mm
  $chip_T = 0.5mm
  $tunnel_W = 3.45mm
  $tunnel_L = 33mm
  $tunnel_r = 0mm
  $q1_x = -15.75mm
  $q2_x = -5.25mm
  $q3_x = 5.25mm
  $q4_x = 15.75mm
  $top_pocket_L = 10mm
  $top_pocket_D = 2.18mm
  $drive_dia = 2.946mm
  $drive_dy = 6.5mm
  $ro_dia = 2.946mm
  $ro_port_len = 8.75mm
  $ro1_x = 0mm
  $ro1_z = -5mm
  $ro2_x = 0mm
  $ro2_z = 5mm
  $ovl = 0.5mm
  $block_L = 80mm
  $block_H = 31.86mm
  $y_front = 12.75mm
  $y_back = 47mm
  $pin_r = 0.635mm
  $ro_pin_len = 5mm
  $drive_pin_gap = 2mm
  $drive_pin_len = $block_H/2 - $drive_pin_gap
  $q_pitch_max = 10.5mm
  $q_pitch = 10.5mm
  $clamp_clear_dia = 3.264mm
  $clamp_cbore_dia = 5.556mm
  $clamp_cbore_depth = 3.2mm
  $clamp_tap_depth = 10mm
  $clamp_thread_depth = 8mm
  $clamp_tap_drill = 2.261mm
  $sma_hole_spacing = 10.795mm
  $sma_tap_depth = 6.3mm
  $sma_thread_depth = 5.5mm
  $sma_tap_drill = 1.778mm
  $sma_flange_T = 1.57mm
  $hw_min_wall = 1mm
  $chip_W = 2.45mm
  $chip_L = 32mm
  $chip_thk = 0.43mm
  $chip_clear = 0.05mm
  $indium_t = 0.1mm
  $chip_slot_W = 2.55mm
  $chip_slot_D = 0.53mm
  $chip_slot_L = 16.68mm
  $bot_pocket_L = 10mm
  $bot_pocket_D = 2.18mm
  $drive_flange_dy = 3.81657225mm
  $drive_flange_dx = 3.81657225mm
  $drive_dy_outer = 6.2mm
  $drive_dy_inner = 6.6mm
materials:
  vacuum: permittivity=1
  cryo_copper: permittivity=1 permeability=1 conductivity=5800000000
  sapphire: permittivity=10
  sapphire_lossless: permittivity=10 permeability=1
surface materials:
  Steel-oxidised-surface

design EM_Cavity (HFSS, Eigenmode, model units mm)
geometry:
  point Clamp_cbore_4-40_sketch = (35mm, -1.71875mm, 15.135mm)
  point Clamp_cbore_4-40_sketch1 = (-35mm, -1.71875mm, 15.135mm)
  point Clamp_cbore_4-40_sketch2 = (35mm, -15.3125mm, 15.135mm)
  point Clamp_cbore_4-40_sketch3 = (-35mm, -15.3125mm, 15.135mm)
  point Clamp_cbore_4-40_sketch4 = (35mm, -28.90625mm, 15.135mm)
  point Clamp_cbore_4-40_sketch5 = (-35mm, -28.90625mm, 15.135mm)
  point Clamp_cbore_4-40_sketch6 = (35mm, -42.5mm, 15.135mm)
  point Clamp_cbore_4-40_sketch7 = (23.333333mm, -42.5mm, 15.135mm)
  point Clamp_cbore_4-40_sketch8 = (11.666667mm, -42.5mm, 15.135mm)
  point Clamp_cbore_4-40_sketch9 = (0mm, -42.5mm, 15.135mm)
  point Clamp_cbore_4-40_sketch10 = (-11.666667mm, -42.5mm, 15.135mm)
  point Clamp_cbore_4-40_sketch11 = (-23.333333mm, -42.5mm, 15.135mm)
  point Clamp_cbore_4-40_sketch12 = (-35mm, -42.5mm, 15.135mm)
  point Clamp_cbore_4-40_sketch13 = (35mm, 11.875mm, 15.135mm)
  point Clamp_cbore_4-40_sketch14 = (24mm, 11.875mm, 15.135mm)
  point Clamp_cbore_4-40_sketch15 = (12mm, 11.875mm, 15.135mm)
  point Clamp_cbore_4-40_sketch16 = (-12mm, 11.875mm, 15.135mm)
  point Clamp_cbore_4-40_sketch17 = (-24mm, 11.875mm, 15.135mm)
  point Clamp_cbore_4-40_sketch18 = (-35mm, 11.875mm, 15.135mm)
  point Clamp_cbore_4-40_sketch19 = (0mm, 0mm, 15.135mm)
  point Clamp_cbore_4-40_sketch20 = (35mm, -1.71875mm, 15.135mm)
  point Clamp_cbore_4-40_sketch21 = (-35mm, -1.71875mm, 15.135mm)
  point Clamp_cbore_4-40_sketch22 = (35mm, -15.3125mm, 15.135mm)
  point Clamp_cbore_4-40_sketch23 = (-35mm, -15.3125mm, 15.135mm)
  point Clamp_cbore_4-40_sketch24 = (35mm, -28.90625mm, 15.135mm)
  point Clamp_cbore_4-40_sketch25 = (-35mm, -28.90625mm, 15.135mm)
  point Clamp_cbore_4-40_sketch26 = (35mm, -42.5mm, 15.135mm)
  point Clamp_cbore_4-40_sketch27 = (23.333333mm, -42.5mm, 15.135mm)
  point Clamp_cbore_4-40_sketch28 = (11.666667mm, -42.5mm, 15.135mm)
  point Clamp_cbore_4-40_sketch29 = (0mm, -42.5mm, 15.135mm)
  point Clamp_cbore_4-40_sketch30 = (-11.666667mm, -42.5mm, 15.135mm)
  point Clamp_cbore_4-40_sketch31 = (-23.333333mm, -42.5mm, 15.135mm)
  point Clamp_cbore_4-40_sketch32 = (-35mm, -42.5mm, 15.135mm)
  point Clamp_cbore_4-40_sketch33 = (35mm, 11.875mm, 15.135mm)
  point Clamp_cbore_4-40_sketch34 = (24mm, 11.875mm, 15.135mm)
  point Clamp_cbore_4-40_sketch35 = (12mm, 11.875mm, 15.135mm)
  point Clamp_cbore_4-40_sketch36 = (-12mm, 11.875mm, 15.135mm)
  point Clamp_cbore_4-40_sketch37 = (-24mm, 11.875mm, 15.135mm)
  point Clamp_cbore_4-40_sketch38 = (-35mm, 11.875mm, 15.135mm)
  point Clamp_cbore_4-40_sketch39 = (0mm, 0mm, 15.135mm)
  point Clamp_cbore_4-40_sketch40 = (35mm, -1.71875mm, 15.135mm)
  point Clamp_cbore_4-40_sketch41 = (-35mm, -1.71875mm, 15.135mm)
  point Clamp_cbore_4-40_sketch42 = (35mm, -15.3125mm, 15.135mm)
  point Clamp_cbore_4-40_sketch43 = (-35mm, -15.3125mm, 15.135mm)
  point Clamp_cbore_4-40_sketch44 = (35mm, -28.90625mm, 15.135mm)
  point Clamp_cbore_4-40_sketch45 = (-35mm, -28.90625mm, 15.135mm)
  point Clamp_cbore_4-40_sketch46 = (35mm, -42.5mm, 15.135mm)
  point Clamp_cbore_4-40_sketch47 = (23.333333mm, -42.5mm, 15.135mm)
  point Clamp_cbore_4-40_sketch48 = (11.666667mm, -42.5mm, 15.135mm)
  point Clamp_cbore_4-40_sketch49 = (0mm, -42.5mm, 15.135mm)
  point Clamp_cbore_4-40_sketch50 = (-11.666667mm, -42.5mm, 15.135mm)
  point Clamp_cbore_4-40_sketch51 = (-23.333333mm, -42.5mm, 15.135mm)
  point Clamp_cbore_4-40_sketch52 = (-35mm, -42.5mm, 15.135mm)
  point Clamp_cbore_4-40_sketch53 = (35mm, 11.875mm, 15.135mm)
  point Clamp_cbore_4-40_sketch54 = (24mm, 11.875mm, 15.135mm)
  point Clamp_cbore_4-40_sketch55 = (12mm, 11.875mm, 15.135mm)
  point Clamp_cbore_4-40_sketch56 = (-12mm, 11.875mm, 15.135mm)
  point Clamp_cbore_4-40_sketch57 = (-24mm, 11.875mm, 15.135mm)
  point Clamp_cbore_4-40_sketch58 = (-35mm, 11.875mm, 15.135mm)
  point Clamp_cbore_4-40_sketch59 = (0mm, 0mm, 15.135mm)
  point Clamp_cbore_4-40_sketch60 = (35mm, -1.71875mm, 15.135mm)
  point Clamp_cbore_4-40_sketch61 = (-35mm, -1.71875mm, 15.135mm)
  point Clamp_cbore_4-40_sketch62 = (35mm, -15.3125mm, 15.135mm)
  point Clamp_cbore_4-40_sketch63 = (-35mm, -15.3125mm, 15.135mm)
  point Clamp_cbore_4-40_sketch64 = (35mm, -28.90625mm, 15.135mm)
  point Clamp_cbore_4-40_sketch65 = (-35mm, -28.90625mm, 15.135mm)
  point Clamp_cbore_4-40_sketch66 = (35mm, -42.5mm, 15.135mm)
  point Clamp_cbore_4-40_sketch67 = (23.333333mm, -42.5mm, 15.135mm)
  point Clamp_cbore_4-40_sketch68 = (11.666667mm, -42.5mm, 15.135mm)
  point Clamp_cbore_4-40_sketch69 = (0mm, -42.5mm, 15.135mm)
  point Clamp_cbore_4-40_sketch70 = (-11.666667mm, -42.5mm, 15.135mm)
  point Clamp_cbore_4-40_sketch71 = (-23.333333mm, -42.5mm, 15.135mm)
  point Clamp_cbore_4-40_sketch72 = (-35mm, -42.5mm, 15.135mm)
  point Clamp_cbore_4-40_sketch73 = (35mm, 11.875mm, 15.135mm)
  point Clamp_cbore_4-40_sketch74 = (24mm, 11.875mm, 15.135mm)
  point Clamp_cbore_4-40_sketch75 = (12mm, 11.875mm, 15.135mm)
  point Clamp_cbore_4-40_sketch76 = (-12mm, 11.875mm, 15.135mm)
  point Clamp_cbore_4-40_sketch77 = (-24mm, 11.875mm, 15.135mm)
  point Clamp_cbore_4-40_sketch78 = (-35mm, 11.875mm, 15.135mm)
  point Clamp_cbore_4-40_sketch79 = (0mm, 0mm, 15.135mm)
  point Clamp_cbore_4-40_sketch80 = (35mm, -3.46875mm, 15.135mm)
  point Clamp_cbore_4-40_sketch81 = (-35mm, -3.46875mm, 15.135mm)
  point Clamp_cbore_4-40_sketch82 = (35mm, -15.3125mm, 15.135mm)
  point Clamp_cbore_4-40_sketch83 = (-35mm, -15.3125mm, 15.135mm)
  point Clamp_cbore_4-40_sketch84 = (35mm, -27.15625mm, 15.135mm)
  point Clamp_cbore_4-40_sketch85 = (-35mm, -27.15625mm, 15.135mm)
  point Clamp_cbore_4-40_sketch86 = (35mm, -39mm, 15.135mm)
  point Clamp_cbore_4-40_sketch87 = (23.333333mm, -39mm, 15.135mm)
  point Clamp_cbore_4-40_sketch88 = (11.666667mm, -39mm, 15.135mm)
  point Clamp_cbore_4-40_sketch89 = (0mm, -39mm, 15.135mm)
  point Clamp_cbore_4-40_sketch90 = (-11.666667mm, -39mm, 15.135mm)
  point Clamp_cbore_4-40_sketch91 = (-23.333333mm, -39mm, 15.135mm)
  point Clamp_cbore_4-40_sketch92 = (-35mm, -39mm, 15.135mm)
  point Clamp_cbore_4-40_sketch93 = (35mm, 8.375mm, 15.135mm)
  point Clamp_cbore_4-40_sketch94 = (24mm, 8.375mm, 15.135mm)
  point Clamp_cbore_4-40_sketch95 = (12mm, 8.375mm, 15.135mm)
  point Clamp_cbore_4-40_sketch96 = (-12mm, 8.375mm, 15.135mm)
  point Clamp_cbore_4-40_sketch97 = (-24mm, 8.375mm, 15.135mm)
  point Clamp_cbore_4-40_sketch98 = (-35mm, 8.375mm, 15.135mm)
  point Clamp_cbore_4-40_sketch99 = (0mm, 0mm, 15.135mm)
  point Clamp_cbore_4-40_sketch100 = (35mm, -3.46875mm, 15.135mm)
  point Clamp_cbore_4-40_sketch101 = (-35mm, -3.46875mm, 15.135mm)
  point Clamp_cbore_4-40_sketch102 = (35mm, -15.3125mm, 15.135mm)
  point Clamp_cbore_4-40_sketch103 = (-35mm, -15.3125mm, 15.135mm)
  point Clamp_cbore_4-40_sketch104 = (35mm, -27.15625mm, 15.135mm)
  point Clamp_cbore_4-40_sketch105 = (-35mm, -27.15625mm, 15.135mm)
  point Clamp_cbore_4-40_sketch106 = (35mm, -39mm, 15.135mm)
  point Clamp_cbore_4-40_sketch107 = (23.333333mm, -39mm, 15.135mm)
  point Clamp_cbore_4-40_sketch108 = (11.666667mm, -39mm, 15.135mm)
  point Clamp_cbore_4-40_sketch109 = (0mm, -39mm, 15.135mm)
  point Clamp_cbore_4-40_sketch110 = (-11.666667mm, -39mm, 15.135mm)
  point Clamp_cbore_4-40_sketch111 = (-23.333333mm, -39mm, 15.135mm)
  point Clamp_cbore_4-40_sketch112 = (-35mm, -39mm, 15.135mm)
  point Clamp_cbore_4-40_sketch113 = (35mm, 8.375mm, 15.135mm)
  point Clamp_cbore_4-40_sketch114 = (24mm, 8.375mm, 15.135mm)
  point Clamp_cbore_4-40_sketch115 = (12mm, 8.375mm, 15.135mm)
  point Clamp_cbore_4-40_sketch116 = (-12mm, 8.375mm, 15.135mm)
  point Clamp_cbore_4-40_sketch117 = (-24mm, 8.375mm, 15.135mm)
  point Clamp_cbore_4-40_sketch118 = (-35mm, 8.375mm, 15.135mm)
  point Clamp_cbore_4-40_sketch119 = (0mm, 0mm, 15.135mm)
  point Clamp_cbore_4-40_sketch120 = (35mm, -3.46875mm, 15.135mm)
  point Clamp_cbore_4-40_sketch121 = (-35mm, -3.46875mm, 15.135mm)
  point Clamp_cbore_4-40_sketch122 = (35mm, -15.3125mm, 15.135mm)
  point Clamp_cbore_4-40_sketch123 = (-35mm, -15.3125mm, 15.135mm)
  point Clamp_cbore_4-40_sketch124 = (35mm, -27.15625mm, 15.135mm)
  point Clamp_cbore_4-40_sketch125 = (-35mm, -27.15625mm, 15.135mm)
  point Clamp_cbore_4-40_sketch126 = (35mm, -39mm, 15.135mm)
  point Clamp_cbore_4-40_sketch127 = (23.333333mm, -39mm, 15.135mm)
  point Clamp_cbore_4-40_sketch128 = (11.666667mm, -39mm, 15.135mm)
  point Clamp_cbore_4-40_sketch129 = (0mm, -39mm, 15.135mm)
  point Clamp_cbore_4-40_sketch130 = (-11.666667mm, -39mm, 15.135mm)
  point Clamp_cbore_4-40_sketch131 = (-23.333333mm, -39mm, 15.135mm)
  point Clamp_cbore_4-40_sketch132 = (-35mm, -39mm, 15.135mm)
  point Clamp_cbore_4-40_sketch133 = (35mm, 8.375mm, 15.135mm)
  point Clamp_cbore_4-40_sketch134 = (24mm, 8.375mm, 15.135mm)
  point Clamp_cbore_4-40_sketch135 = (12mm, 8.375mm, 15.135mm)
  point Clamp_cbore_4-40_sketch136 = (-12mm, 8.375mm, 15.135mm)
  point Clamp_cbore_4-40_sketch137 = (-24mm, 8.375mm, 15.135mm)
  point Clamp_cbore_4-40_sketch138 = (-35mm, 8.375mm, 15.135mm)
  point Clamp_cbore_4-40_sketch139 = (0mm, 0mm, 15.135mm)
  point Clamp_cbore_4-40_sketch140 = (35mm, -3.46875mm, 15.135mm)
  point Clamp_cbore_4-40_sketch141 = (-35mm, -3.46875mm, 15.135mm)
  point Clamp_cbore_4-40_sketch142 = (35mm, -15.3125mm, 15.135mm)
  point Clamp_cbore_4-40_sketch143 = (-35mm, -15.3125mm, 15.135mm)
  point Clamp_cbore_4-40_sketch144 = (35mm, -27.15625mm, 15.135mm)
  point Clamp_cbore_4-40_sketch145 = (-35mm, -27.15625mm, 15.135mm)
  point Clamp_cbore_4-40_sketch146 = (35mm, -39mm, 15.135mm)
  point Clamp_cbore_4-40_sketch147 = (23.333333mm, -39mm, 15.135mm)
  point Clamp_cbore_4-40_sketch148 = (11.666667mm, -39mm, 15.135mm)
  point Clamp_cbore_4-40_sketch149 = (0mm, -39mm, 15.135mm)
  point Clamp_cbore_4-40_sketch150 = (-11.666667mm, -39mm, 15.135mm)
  point Clamp_cbore_4-40_sketch151 = (-23.333333mm, -39mm, 15.135mm)
  point Clamp_cbore_4-40_sketch152 = (-35mm, -39mm, 15.135mm)
  point Clamp_cbore_4-40_sketch153 = (35mm, 8.375mm, 15.135mm)
  point Clamp_cbore_4-40_sketch154 = (24mm, 8.375mm, 15.135mm)
  point Clamp_cbore_4-40_sketch155 = (12mm, 8.375mm, 15.135mm)
  point Clamp_cbore_4-40_sketch156 = (-12mm, 8.375mm, 15.135mm)
  point Clamp_cbore_4-40_sketch157 = (-24mm, 8.375mm, 15.135mm)
  point Clamp_cbore_4-40_sketch158 = (-35mm, 8.375mm, 15.135mm)
  point Clamp_cbore_4-40_sketch159 = (0mm, 0mm, 15.135mm)
  point Clamp_cbore_4-40_sketch160 = (35mm, -3.46875mm, 15.135mm)
  point Clamp_cbore_4-40_sketch161 = (-35mm, -3.46875mm, 15.135mm)
  point Clamp_cbore_4-40_sketch162 = (35mm, -15.3125mm, 15.135mm)
  point Clamp_cbore_4-40_sketch163 = (-35mm, -15.3125mm, 15.135mm)
  point Clamp_cbore_4-40_sketch164 = (35mm, -27.15625mm, 15.135mm)
  point Clamp_cbore_4-40_sketch165 = (-35mm, -27.15625mm, 15.135mm)
  point Clamp_cbore_4-40_sketch166 = (35mm, -39mm, 15.135mm)
  point Clamp_cbore_4-40_sketch167 = (23.333333mm, -39mm, 15.135mm)
  point Clamp_cbore_4-40_sketch168 = (11.666667mm, -39mm, 15.135mm)
  point Clamp_cbore_4-40_sketch169 = (0mm, -39mm, 15.135mm)
  point Clamp_cbore_4-40_sketch170 = (-11.666667mm, -39mm, 15.135mm)
  point Clamp_cbore_4-40_sketch171 = (-23.333333mm, -39mm, 15.135mm)
  point Clamp_cbore_4-40_sketch172 = (-35mm, -39mm, 15.135mm)
  point Clamp_cbore_4-40_sketch173 = (35mm, 8.375mm, 15.135mm)
  point Clamp_cbore_4-40_sketch174 = (24mm, 8.375mm, 15.135mm)
  point Clamp_cbore_4-40_sketch175 = (12mm, 8.375mm, 15.135mm)
  point Clamp_cbore_4-40_sketch176 = (-12mm, 8.375mm, 15.135mm)
  point Clamp_cbore_4-40_sketch177 = (-24mm, 8.375mm, 15.135mm)
  point Clamp_cbore_4-40_sketch178 = (-35mm, 8.375mm, 15.135mm)
  point Clamp_cbore_4-40_sketch179 = (0mm, 0mm, 15.135mm)
  point Clamp_cbore_4-40_sketch180 = (35mm, -3.46875mm, 15.135mm)
  point Clamp_cbore_4-40_sketch181 = (-35mm, -3.46875mm, 15.135mm)
  point Clamp_cbore_4-40_sketch182 = (35mm, -15.3125mm, 15.135mm)
  point Clamp_cbore_4-40_sketch183 = (-35mm, -15.3125mm, 15.135mm)
  point Clamp_cbore_4-40_sketch184 = (35mm, -27.15625mm, 15.135mm)
  point Clamp_cbore_4-40_sketch185 = (-35mm, -27.15625mm, 15.135mm)
  point Clamp_cbore_4-40_sketch186 = (35mm, -39mm, 15.135mm)
  point Clamp_cbore_4-40_sketch187 = (23.333333mm, -39mm, 15.135mm)
  point Clamp_cbore_4-40_sketch188 = (11.666667mm, -39mm, 15.135mm)
  point Clamp_cbore_4-40_sketch189 = (0mm, -39mm, 15.135mm)
  point Clamp_cbore_4-40_sketch190 = (-11.666667mm, -39mm, 15.135mm)
  point Clamp_cbore_4-40_sketch191 = (-23.333333mm, -39mm, 15.135mm)
  point Clamp_cbore_4-40_sketch192 = (-35mm, -39mm, 15.135mm)
  point Clamp_cbore_4-40_sketch193 = (35mm, 8.375mm, 15.135mm)
  point Clamp_cbore_4-40_sketch194 = (24mm, 8.375mm, 15.135mm)
  point Clamp_cbore_4-40_sketch195 = (12mm, 8.375mm, 15.135mm)
  point Clamp_cbore_4-40_sketch196 = (-12mm, 8.375mm, 15.135mm)
  point Clamp_cbore_4-40_sketch197 = (-24mm, 8.375mm, 15.135mm)
  point Clamp_cbore_4-40_sketch198 = (-35mm, 8.375mm, 15.135mm)
  point Clamp_cbore_4-40_sketch199 = (0mm, 0mm, 15.135mm)
  point Clamp_cbore_4-40_sketch200 = (35mm, -3.46875mm, 15.135mm)
  point Clamp_cbore_4-40_sketch201 = (-35mm, -3.46875mm, 15.135mm)
  point Clamp_cbore_4-40_sketch202 = (35mm, -15.3125mm, 15.135mm)
  point Clamp_cbore_4-40_sketch203 = (-35mm, -15.3125mm, 15.135mm)
  point Clamp_cbore_4-40_sketch204 = (35mm, -27.15625mm, 15.135mm)
  point Clamp_cbore_4-40_sketch205 = (-35mm, -27.15625mm, 15.135mm)
  point Clamp_cbore_4-40_sketch206 = (35mm, -39mm, 15.135mm)
  point Clamp_cbore_4-40_sketch207 = (23.333333mm, -39mm, 15.135mm)
  point Clamp_cbore_4-40_sketch208 = (11.666667mm, -39mm, 15.135mm)
  point Clamp_cbore_4-40_sketch209 = (0mm, -39mm, 15.135mm)
  point Clamp_cbore_4-40_sketch210 = (-11.666667mm, -39mm, 15.135mm)
  point Clamp_cbore_4-40_sketch211 = (-23.333333mm, -39mm, 15.135mm)
  point Clamp_cbore_4-40_sketch212 = (-35mm, -39mm, 15.135mm)
  point Clamp_cbore_4-40_sketch213 = (35mm, 8.375mm, 15.135mm)
  point Clamp_cbore_4-40_sketch214 = (24mm, 8.375mm, 15.135mm)
  point Clamp_cbore_4-40_sketch215 = (12mm, 8.375mm, 15.135mm)
  point Clamp_cbore_4-40_sketch216 = (-12mm, 8.375mm, 15.135mm)
  point Clamp_cbore_4-40_sketch217 = (-24mm, 8.375mm, 15.135mm)
  point Clamp_cbore_4-40_sketch218 = (-35mm, 8.375mm, 15.135mm)
  point Clamp_cbore_4-40_sketch219 = (0mm, 0mm, 15.135mm)
  point Clamp_cbore_4-40_sketch220 = (35mm, -15.3125mm, 15.135mm)
  point Clamp_cbore_4-40_sketch221 = (-35mm, -15.3125mm, 15.135mm)
  point Clamp_cbore_4-40_sketch222 = (35mm, -39mm, 15.135mm)
  point Clamp_cbore_4-40_sketch223 = (0mm, -39mm, 15.135mm)
  point Clamp_cbore_4-40_sketch224 = (-35mm, -39mm, 15.135mm)
  point Clamp_cbore_4-40_sketch225 = (35mm, 8.375mm, 15.135mm)
  point Clamp_cbore_4-40_sketch226 = (12mm, 8.375mm, 15.135mm)
  point Clamp_cbore_4-40_sketch227 = (-12mm, 8.375mm, 15.135mm)
  point Clamp_cbore_4-40_sketch228 = (-35mm, 8.375mm, 15.135mm)
  point Clamp_cbore_4-40_sketch229 = (0mm, 0mm, 15.135mm)
  point Clamp_cbore_4-40_sketch230 = (35mm, -15.3125mm, 15.135mm)
  point Clamp_cbore_4-40_sketch231 = (-35mm, -15.3125mm, 15.135mm)
  point Clamp_cbore_4-40_sketch232 = (35mm, -39mm, 15.135mm)
  point Clamp_cbore_4-40_sketch233 = (0mm, -39mm, 15.135mm)
  point Clamp_cbore_4-40_sketch234 = (-35mm, -39mm, 15.135mm)
  point Clamp_cbore_4-40_sketch235 = (35mm, 8.375mm, 15.135mm)
  point Clamp_cbore_4-40_sketch236 = (12mm, 8.375mm, 15.135mm)
  point Clamp_cbore_4-40_sketch237 = (-12mm, 8.375mm, 15.135mm)
  point Clamp_cbore_4-40_sketch238 = (-35mm, 8.375mm, 15.135mm)
  point Clamp_cbore_4-40_sketch239 = (0mm, 0mm, 15.135mm)
  point Clamp_cbore_4-40_sketch240 = (35mm, -9.6275mm, 15.135mm)
  point Clamp_cbore_4-40_sketch241 = (-35mm, -9.6275mm, 15.135mm)
  point Clamp_cbore_4-40_sketch242 = (35mm, -27.63mm, 15.135mm)
  point Clamp_cbore_4-40_sketch243 = (0mm, -27.63mm, 15.135mm)
  point Clamp_cbore_4-40_sketch244 = (-35mm, -27.63mm, 15.135mm)
  point Clamp_cbore_4-40_sketch245 = (35mm, 8.375mm, 15.135mm)
  point Clamp_cbore_4-40_sketch246 = (12mm, 8.375mm, 15.135mm)
  point Clamp_cbore_4-40_sketch247 = (-12mm, 8.375mm, 15.135mm)
  point Clamp_cbore_4-40_sketch248 = (-35mm, 8.375mm, 15.135mm)
  point Clamp_cbore_4-40_sketch249 = (0mm, 0mm, 15.135mm)
  point Clamp_cbore_4-40_sketch250 = (35mm, -9.6275mm, 15.135mm)
  point Clamp_cbore_4-40_sketch251 = (-35mm, -9.6275mm, 15.135mm)
  point Clamp_cbore_4-40_sketch252 = (35mm, -27.63mm, 15.135mm)
  point Clamp_cbore_4-40_sketch253 = (0mm, -27.63mm, 15.135mm)
  point Clamp_cbore_4-40_sketch254 = (-35mm, -27.63mm, 15.135mm)
  point Clamp_cbore_4-40_sketch255 = (35mm, 8.375mm, 15.135mm)
  point Clamp_cbore_4-40_sketch256 = (12mm, 8.375mm, 15.135mm)
  point Clamp_cbore_4-40_sketch257 = (-12mm, 8.375mm, 15.135mm)
  point Clamp_cbore_4-40_sketch258 = (-35mm, 8.375mm, 15.135mm)
  point Clamp_cbore_4-40_sketch259 = (0mm, 0mm, 15.135mm)
  point Clamp_cbore_4-40_sketch260 = (35mm, -9.6275mm, 15.135mm)
  point Clamp_cbore_4-40_sketch261 = (-35mm, -9.6275mm, 15.135mm)
  point Clamp_cbore_4-40_sketch262 = (35mm, -27.63mm, 15.135mm)
  point Clamp_cbore_4-40_sketch263 = (0mm, -27.63mm, 15.135mm)
  point Clamp_cbore_4-40_sketch264 = (-35mm, -27.63mm, 15.135mm)
  point Clamp_cbore_4-40_sketch265 = (35mm, 8.375mm, 15.135mm)
  point Clamp_cbore_4-40_sketch266 = (12mm, 8.375mm, 15.135mm)
  point Clamp_cbore_4-40_sketch267 = (-12mm, 8.375mm, 15.135mm)
  point Clamp_cbore_4-40_sketch268 = (-35mm, 8.375mm, 15.135mm)
  point Clamp_cbore_4-40_sketch269 = (0mm, 0mm, 15.135mm)
  point Clamp_cbore_4-40_sketch270 = (35mm, -9.6275mm, 15.135mm)
  point Clamp_cbore_4-40_sketch271 = (-35mm, -9.6275mm, 15.135mm)
  point Clamp_cbore_4-40_sketch272 = (35mm, -27.63mm, 15.135mm)
  point Clamp_cbore_4-40_sketch273 = (0mm, -27.63mm, 15.135mm)
  point Clamp_cbore_4-40_sketch274 = (-35mm, -27.63mm, 15.135mm)
  point Clamp_cbore_4-40_sketch275 = (35mm, 8.375mm, 15.135mm)
  point Clamp_cbore_4-40_sketch276 = (12mm, 8.375mm, 15.135mm)
  point Clamp_cbore_4-40_sketch277 = (-12mm, 8.375mm, 15.135mm)
  point Clamp_cbore_4-40_sketch278 = (-35mm, 8.375mm, 15.135mm)
  point Clamp_cbore_4-40_sketch279 = (0mm, 0mm, 15.135mm)
  point Clamp_cbore_4-40_sketch280 = (35mm, -9.6275mm, 15.135mm)
  point Clamp_cbore_4-40_sketch281 = (-35mm, -9.6275mm, 15.135mm)
  point Clamp_cbore_4-40_sketch282 = (35mm, -27.63mm, 15.135mm)
  point Clamp_cbore_4-40_sketch283 = (0mm, -27.63mm, 15.135mm)
  point Clamp_cbore_4-40_sketch284 = (-35mm, -27.63mm, 15.135mm)
  point Clamp_cbore_4-40_sketch285 = (35mm, 8.375mm, 15.135mm)
  point Clamp_cbore_4-40_sketch286 = (12mm, 8.375mm, 15.135mm)
  point Clamp_cbore_4-40_sketch287 = (-12mm, 8.375mm, 15.135mm)
  point Clamp_cbore_4-40_sketch288 = (-35mm, 8.375mm, 15.135mm)
  point Clamp_cbore_4-40_sketch289 = (0mm, 0mm, 15.135mm)
  point Clamp_cbore_4-40_sketch290 = (35mm, -9.6275mm, 15.135mm)
  point Clamp_cbore_4-40_sketch291 = (-35mm, -9.6275mm, 15.135mm)
  point Clamp_cbore_4-40_sketch292 = (35mm, -27.63mm, 15.135mm)
  point Clamp_cbore_4-40_sketch293 = (0mm, -27.63mm, 15.135mm)
  point Clamp_cbore_4-40_sketch294 = (-35mm, -27.63mm, 15.135mm)
  point Clamp_cbore_4-40_sketch295 = (35mm, 8.375mm, 15.135mm)
  point Clamp_cbore_4-40_sketch296 = (12mm, 8.375mm, 15.135mm)
  point Clamp_cbore_4-40_sketch297 = (-12mm, 8.375mm, 15.135mm)
  point Clamp_cbore_4-40_sketch298 = (-35mm, 8.375mm, 15.135mm)
  point Clamp_cbore_4-40_sketch299 = (0mm, 0mm, 15.135mm)
  point Clamp_cbore_4-40_sketch300 = (35mm, -16.8125mm, 15.93mm)
  point Clamp_cbore_4-40_sketch301 = (-35mm, -16.8125mm, 15.93mm)
  point Clamp_cbore_4-40_sketch302 = (35mm, -42mm, 15.93mm)
  point Clamp_cbore_4-40_sketch303 = (0mm, -42mm, 15.93mm)
  point Clamp_cbore_4-40_sketch304 = (-35mm, -42mm, 15.93mm)
  point Clamp_cbore_4-40_sketch305 = (35mm, 8.375mm, 15.93mm)
  point Clamp_cbore_4-40_sketch306 = (12mm, 8.375mm, 15.93mm)
  point Clamp_cbore_4-40_sketch307 = (-12mm, 8.375mm, 15.93mm)
  point Clamp_cbore_4-40_sketch308 = (-35mm, 8.375mm, 15.93mm)
  point Clamp_cbore_4-40_sketch309 = (0mm, 0mm, 15.93mm)
  Solid1, Solid1_1 = imported_body(C:\Users\epm114\Documents\GitHub\Cavity work\coffin_4Q\inventor_files\coffin_4Q_hfss.stp)
  cavity [vacuum] = box(corner=(-40mm, -47mm, -15.93mm), size=(80mm, 59.75mm, 31.86mm))
  cavity.subtract(Solid1, Solid1_1)
  ro_pin_1 = cylinder(axis=Y, base_centre=($ro1_x, $y_front - $ro_pin_len, $ro1_z), radius=$pin_r, height=$ro_pin_len)
  ro_pin_2 = cylinder(axis=Y, base_centre=($ro2_x, $y_front - $ro_pin_len, $ro2_z), radius=$pin_r, height=$ro_pin_len)
  drive_pin_1 = cylinder(axis=Z, base_centre=($q1_x, -($cav_W/2 + $drive_dy_outer), $block_H/2 - $drive_pin_len), radius=$pin_r, height=$drive_pin_len)
  drive_pin_2 = cylinder(axis=Z, base_centre=($q2_x, -($cav_W/2 + $drive_dy_inner), $block_H/2 - $drive_pin_len), radius=$pin_r, height=$drive_pin_len)
  drive_pin_3 = cylinder(axis=Z, base_centre=($q3_x, -($cav_W/2 + $drive_dy_inner), $block_H/2 - $drive_pin_len), radius=$pin_r, height=$drive_pin_len)
  drive_pin_4 = cylinder(axis=Z, base_centre=($q4_x, -($cav_W/2 + $drive_dy_outer), $block_H/2 - $drive_pin_len), radius=$pin_r, height=$drive_pin_len)
  cavity.subtract(ro_pin_1, ro_pin_2, drive_pin_1..drive_pin_4)
boundaries and excitations:
  ro1: Impedance Faces=cavity.face(at (0, 12.75, -5)) Resistance=373.3629 Reactance=0
  ro2: Impedance Faces=cavity.face(at (0, 12.75, 5)) Resistance=373.3629 Reactance=0
  drive1: Impedance Faces=cavity.face(at (-15.75, -10.2, 15.93)) Resistance=373.3629 Reactance=0
  drive2: Impedance Faces=cavity.face(at (-5.25, -10.6, 15.93)) Resistance=373.3629 Reactance=0
  drive3: Impedance Faces=cavity.face(at (5.25, -10.6, 15.93)) Resistance=373.3629 Reactance=0
  drive4: Impedance Faces=cavity.face(at (15.75, -10.2, 15.93)) Resistance=373.3629 Reactance=0
  cryo_copper: Finite Conductivity Faces=cavity.face(at (5.25, -25.5, 0), at (-5.25, -25.5, 0), at (-15.75, -25.5, 0), at (0, 0, 10.93), at (-29.4142, -3.41421, 0), at (0, -4, 0), at (29.4142, -3.41421, 0), at (30, 0, 0), at (29.4142, 3.41421, 0), at (0, 4, 0), at (-29.4142, 3.41421, 0), at (-30, 0, 0)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) UseMaterial Material=cryo_copper IsInternal
setups:
  EM_Cavity: HfssEigen MinimumFrequency=5GHz NumModes=10 MaxDeltaFreq=0.05 ConvergeOnRealFreq=true MaximumPasses=20 MinimumPasses=2 MinimumConvergedPasses=2 PercentRefinement=30 BasisOrder=-1
source amplitudes:
  #-10:1, #-10:2, #-10:3, #-10:5..#-10:10: 0 0
  #-10:4: 1 0
field plots:
  MagE_mode1_XY: MagE_mode1_XY over a plane on EM_Cavity : LastAdaptive at Phase=0deg
  MagE_mode1_YZ: MagE_mode1_YZ over a plane on EM_Cavity : LastAdaptive at Phase=0deg
  MagE_mode5_XY: MagE_mode5_XY over a plane on EM_Cavity : LastAdaptive at Phase=0deg
  MagE_mode5_YZ: MagE_mode5_YZ over a plane on EM_Cavity : LastAdaptive at Phase=0deg
  MagE_mode6_XY: MagE_mode6_XY over a plane on EM_Cavity : LastAdaptive at Phase=0deg
  MagE_mode6_YZ: MagE_mode6_YZ over a plane on EM_Cavity : LastAdaptive at Phase=0deg
  MagE_mode2_XY: MagE_mode2_XY over a plane on EM_Cavity : LastAdaptive at Phase=0deg
  MagE_mode2_YZ: MagE_mode2_YZ over a plane on EM_Cavity : LastAdaptive at Phase=0deg
  MagE_mode3_XY: MagE_mode3_XY over a plane on EM_Cavity : LastAdaptive at Phase=0deg
  MagE_mode3_YZ: MagE_mode3_YZ over a plane on EM_Cavity : LastAdaptive at Phase=0deg
  MagE_mode4_XY: MagE_mode4_XY over a plane on EM_Cavity : LastAdaptive at Phase=0deg
  MagE_mode4_YZ: MagE_mode4_YZ over a plane on EM_Cavity : LastAdaptive at Phase=0deg

design EM_Cavity_with_Transmons (HFSS, Eigenmode, model units mm)
variables:
  Lj1 = 9.5nH
  Lj2 = 10.5nH
  Lj3 = 11.5nH
  Lj4 = 12.5nH
geometry:
  point Clamp_cbore_4-40_sketch = (35mm, -1.71875mm, 15.135mm)
  point Clamp_cbore_4-40_sketch1 = (-35mm, -1.71875mm, 15.135mm)
  point Clamp_cbore_4-40_sketch2 = (35mm, -15.3125mm, 15.135mm)
  point Clamp_cbore_4-40_sketch3 = (-35mm, -15.3125mm, 15.135mm)
  point Clamp_cbore_4-40_sketch4 = (35mm, -28.90625mm, 15.135mm)
  point Clamp_cbore_4-40_sketch5 = (-35mm, -28.90625mm, 15.135mm)
  point Clamp_cbore_4-40_sketch6 = (35mm, -42.5mm, 15.135mm)
  point Clamp_cbore_4-40_sketch7 = (23.333333mm, -42.5mm, 15.135mm)
  point Clamp_cbore_4-40_sketch8 = (11.666667mm, -42.5mm, 15.135mm)
  point Clamp_cbore_4-40_sketch9 = (0mm, -42.5mm, 15.135mm)
  point Clamp_cbore_4-40_sketch10 = (-11.666667mm, -42.5mm, 15.135mm)
  point Clamp_cbore_4-40_sketch11 = (-23.333333mm, -42.5mm, 15.135mm)
  point Clamp_cbore_4-40_sketch12 = (-35mm, -42.5mm, 15.135mm)
  point Clamp_cbore_4-40_sketch13 = (35mm, 11.875mm, 15.135mm)
  point Clamp_cbore_4-40_sketch14 = (24mm, 11.875mm, 15.135mm)
  point Clamp_cbore_4-40_sketch15 = (12mm, 11.875mm, 15.135mm)
  point Clamp_cbore_4-40_sketch16 = (-12mm, 11.875mm, 15.135mm)
  point Clamp_cbore_4-40_sketch17 = (-24mm, 11.875mm, 15.135mm)
  point Clamp_cbore_4-40_sketch18 = (-35mm, 11.875mm, 15.135mm)
  point Clamp_cbore_4-40_sketch19 = (0mm, 0mm, 15.135mm)
  point Clamp_cbore_4-40_sketch20 = (35mm, -1.71875mm, 15.135mm)
  point Clamp_cbore_4-40_sketch21 = (-35mm, -1.71875mm, 15.135mm)
  point Clamp_cbore_4-40_sketch22 = (35mm, -15.3125mm, 15.135mm)
  point Clamp_cbore_4-40_sketch23 = (-35mm, -15.3125mm, 15.135mm)
  point Clamp_cbore_4-40_sketch24 = (35mm, -28.90625mm, 15.135mm)
  point Clamp_cbore_4-40_sketch25 = (-35mm, -28.90625mm, 15.135mm)
  point Clamp_cbore_4-40_sketch26 = (35mm, -42.5mm, 15.135mm)
  point Clamp_cbore_4-40_sketch27 = (23.333333mm, -42.5mm, 15.135mm)
  point Clamp_cbore_4-40_sketch28 = (11.666667mm, -42.5mm, 15.135mm)
  point Clamp_cbore_4-40_sketch29 = (0mm, -42.5mm, 15.135mm)
  point Clamp_cbore_4-40_sketch30 = (-11.666667mm, -42.5mm, 15.135mm)
  point Clamp_cbore_4-40_sketch31 = (-23.333333mm, -42.5mm, 15.135mm)
  point Clamp_cbore_4-40_sketch32 = (-35mm, -42.5mm, 15.135mm)
  point Clamp_cbore_4-40_sketch33 = (35mm, 11.875mm, 15.135mm)
  point Clamp_cbore_4-40_sketch34 = (24mm, 11.875mm, 15.135mm)
  point Clamp_cbore_4-40_sketch35 = (12mm, 11.875mm, 15.135mm)
  point Clamp_cbore_4-40_sketch36 = (-12mm, 11.875mm, 15.135mm)
  point Clamp_cbore_4-40_sketch37 = (-24mm, 11.875mm, 15.135mm)
  point Clamp_cbore_4-40_sketch38 = (-35mm, 11.875mm, 15.135mm)
  point Clamp_cbore_4-40_sketch39 = (0mm, 0mm, 15.135mm)
  point Clamp_cbore_4-40_sketch40 = (35mm, -3.46875mm, 15.135mm)
  point Clamp_cbore_4-40_sketch41 = (-35mm, -3.46875mm, 15.135mm)
  point Clamp_cbore_4-40_sketch42 = (35mm, -15.3125mm, 15.135mm)
  point Clamp_cbore_4-40_sketch43 = (-35mm, -15.3125mm, 15.135mm)
  point Clamp_cbore_4-40_sketch44 = (35mm, -27.15625mm, 15.135mm)
  point Clamp_cbore_4-40_sketch45 = (-35mm, -27.15625mm, 15.135mm)
  point Clamp_cbore_4-40_sketch46 = (35mm, -39mm, 15.135mm)
  point Clamp_cbore_4-40_sketch47 = (23.333333mm, -39mm, 15.135mm)
  point Clamp_cbore_4-40_sketch48 = (11.666667mm, -39mm, 15.135mm)
  point Clamp_cbore_4-40_sketch49 = (0mm, -39mm, 15.135mm)
  point Clamp_cbore_4-40_sketch50 = (-11.666667mm, -39mm, 15.135mm)
  point Clamp_cbore_4-40_sketch51 = (-23.333333mm, -39mm, 15.135mm)
  point Clamp_cbore_4-40_sketch52 = (-35mm, -39mm, 15.135mm)
  point Clamp_cbore_4-40_sketch53 = (35mm, 8.375mm, 15.135mm)
  point Clamp_cbore_4-40_sketch54 = (24mm, 8.375mm, 15.135mm)
  point Clamp_cbore_4-40_sketch55 = (12mm, 8.375mm, 15.135mm)
  point Clamp_cbore_4-40_sketch56 = (-12mm, 8.375mm, 15.135mm)
  point Clamp_cbore_4-40_sketch57 = (-24mm, 8.375mm, 15.135mm)
  point Clamp_cbore_4-40_sketch58 = (-35mm, 8.375mm, 15.135mm)
  point Clamp_cbore_4-40_sketch59 = (0mm, 0mm, 15.135mm)
  point Clamp_cbore_4-40_sketch60 = (35mm, -3.46875mm, 15.135mm)
  point Clamp_cbore_4-40_sketch61 = (-35mm, -3.46875mm, 15.135mm)
  point Clamp_cbore_4-40_sketch62 = (35mm, -15.3125mm, 15.135mm)
  point Clamp_cbore_4-40_sketch63 = (-35mm, -15.3125mm, 15.135mm)
  point Clamp_cbore_4-40_sketch64 = (35mm, -27.15625mm, 15.135mm)
  point Clamp_cbore_4-40_sketch65 = (-35mm, -27.15625mm, 15.135mm)
  point Clamp_cbore_4-40_sketch66 = (35mm, -39mm, 15.135mm)
  point Clamp_cbore_4-40_sketch67 = (23.333333mm, -39mm, 15.135mm)
  point Clamp_cbore_4-40_sketch68 = (11.666667mm, -39mm, 15.135mm)
  point Clamp_cbore_4-40_sketch69 = (0mm, -39mm, 15.135mm)
  point Clamp_cbore_4-40_sketch70 = (-11.666667mm, -39mm, 15.135mm)
  point Clamp_cbore_4-40_sketch71 = (-23.333333mm, -39mm, 15.135mm)
  point Clamp_cbore_4-40_sketch72 = (-35mm, -39mm, 15.135mm)
  point Clamp_cbore_4-40_sketch73 = (35mm, 8.375mm, 15.135mm)
  point Clamp_cbore_4-40_sketch74 = (24mm, 8.375mm, 15.135mm)
  point Clamp_cbore_4-40_sketch75 = (12mm, 8.375mm, 15.135mm)
  point Clamp_cbore_4-40_sketch76 = (-12mm, 8.375mm, 15.135mm)
  point Clamp_cbore_4-40_sketch77 = (-24mm, 8.375mm, 15.135mm)
  point Clamp_cbore_4-40_sketch78 = (-35mm, 8.375mm, 15.135mm)
  point Clamp_cbore_4-40_sketch79 = (0mm, 0mm, 15.135mm)
  point Clamp_cbore_4-40_sketch80 = (35mm, -3.46875mm, 15.135mm)
  point Clamp_cbore_4-40_sketch81 = (-35mm, -3.46875mm, 15.135mm)
  point Clamp_cbore_4-40_sketch82 = (35mm, -15.3125mm, 15.135mm)
  point Clamp_cbore_4-40_sketch83 = (-35mm, -15.3125mm, 15.135mm)
  point Clamp_cbore_4-40_sketch84 = (35mm, -27.15625mm, 15.135mm)
  point Clamp_cbore_4-40_sketch85 = (-35mm, -27.15625mm, 15.135mm)
  point Clamp_cbore_4-40_sketch86 = (35mm, -39mm, 15.135mm)
  point Clamp_cbore_4-40_sketch87 = (23.333333mm, -39mm, 15.135mm)
  point Clamp_cbore_4-40_sketch88 = (11.666667mm, -39mm, 15.135mm)
  point Clamp_cbore_4-40_sketch89 = (0mm, -39mm, 15.135mm)
  point Clamp_cbore_4-40_sketch90 = (-11.666667mm, -39mm, 15.135mm)
  point Clamp_cbore_4-40_sketch91 = (-23.333333mm, -39mm, 15.135mm)
  point Clamp_cbore_4-40_sketch92 = (-35mm, -39mm, 15.135mm)
  point Clamp_cbore_4-40_sketch93 = (35mm, 8.375mm, 15.135mm)
  point Clamp_cbore_4-40_sketch94 = (24mm, 8.375mm, 15.135mm)
  point Clamp_cbore_4-40_sketch95 = (12mm, 8.375mm, 15.135mm)
  point Clamp_cbore_4-40_sketch96 = (-12mm, 8.375mm, 15.135mm)
  point Clamp_cbore_4-40_sketch97 = (-24mm, 8.375mm, 15.135mm)
  point Clamp_cbore_4-40_sketch98 = (-35mm, 8.375mm, 15.135mm)
  point Clamp_cbore_4-40_sketch99 = (0mm, 0mm, 15.135mm)
  point Clamp_cbore_4-40_sketch100 = (35mm, -3.46875mm, 15.135mm)
  point Clamp_cbore_4-40_sketch101 = (-35mm, -3.46875mm, 15.135mm)
  point Clamp_cbore_4-40_sketch102 = (35mm, -15.3125mm, 15.135mm)
  point Clamp_cbore_4-40_sketch103 = (-35mm, -15.3125mm, 15.135mm)
  point Clamp_cbore_4-40_sketch104 = (35mm, -27.15625mm, 15.135mm)
  point Clamp_cbore_4-40_sketch105 = (-35mm, -27.15625mm, 15.135mm)
  point Clamp_cbore_4-40_sketch106 = (35mm, -39mm, 15.135mm)
  point Clamp_cbore_4-40_sketch107 = (23.333333mm, -39mm, 15.135mm)
  point Clamp_cbore_4-40_sketch108 = (11.666667mm, -39mm, 15.135mm)
  point Clamp_cbore_4-40_sketch109 = (0mm, -39mm, 15.135mm)
  point Clamp_cbore_4-40_sketch110 = (-11.666667mm, -39mm, 15.135mm)
  point Clamp_cbore_4-40_sketch111 = (-23.333333mm, -39mm, 15.135mm)
  point Clamp_cbore_4-40_sketch112 = (-35mm, -39mm, 15.135mm)
  point Clamp_cbore_4-40_sketch113 = (35mm, 8.375mm, 15.135mm)
  point Clamp_cbore_4-40_sketch114 = (24mm, 8.375mm, 15.135mm)
  point Clamp_cbore_4-40_sketch115 = (12mm, 8.375mm, 15.135mm)
  point Clamp_cbore_4-40_sketch116 = (-12mm, 8.375mm, 15.135mm)
  point Clamp_cbore_4-40_sketch117 = (-24mm, 8.375mm, 15.135mm)
  point Clamp_cbore_4-40_sketch118 = (-35mm, 8.375mm, 15.135mm)
  point Clamp_cbore_4-40_sketch119 = (0mm, 0mm, 15.135mm)
  point Clamp_cbore_4-40_sketch120 = (35mm, -3.46875mm, 15.135mm)
  point Clamp_cbore_4-40_sketch121 = (-35mm, -3.46875mm, 15.135mm)
  point Clamp_cbore_4-40_sketch122 = (35mm, -15.3125mm, 15.135mm)
  point Clamp_cbore_4-40_sketch123 = (-35mm, -15.3125mm, 15.135mm)
  point Clamp_cbore_4-40_sketch124 = (35mm, -27.15625mm, 15.135mm)
  point Clamp_cbore_4-40_sketch125 = (-35mm, -27.15625mm, 15.135mm)
  point Clamp_cbore_4-40_sketch126 = (35mm, -39mm, 15.135mm)
  point Clamp_cbore_4-40_sketch127 = (23.333333mm, -39mm, 15.135mm)
  point Clamp_cbore_4-40_sketch128 = (11.666667mm, -39mm, 15.135mm)
  point Clamp_cbore_4-40_sketch129 = (0mm, -39mm, 15.135mm)
  point Clamp_cbore_4-40_sketch130 = (-11.666667mm, -39mm, 15.135mm)
  point Clamp_cbore_4-40_sketch131 = (-23.333333mm, -39mm, 15.135mm)
  point Clamp_cbore_4-40_sketch132 = (-35mm, -39mm, 15.135mm)
  point Clamp_cbore_4-40_sketch133 = (35mm, 8.375mm, 15.135mm)
  point Clamp_cbore_4-40_sketch134 = (24mm, 8.375mm, 15.135mm)
  point Clamp_cbore_4-40_sketch135 = (12mm, 8.375mm, 15.135mm)
  point Clamp_cbore_4-40_sketch136 = (-12mm, 8.375mm, 15.135mm)
  point Clamp_cbore_4-40_sketch137 = (-24mm, 8.375mm, 15.135mm)
  point Clamp_cbore_4-40_sketch138 = (-35mm, 8.375mm, 15.135mm)
  point Clamp_cbore_4-40_sketch139 = (0mm, 0mm, 15.135mm)
  point Clamp_cbore_4-40_sketch140 = (35mm, -3.46875mm, 15.135mm)
  point Clamp_cbore_4-40_sketch141 = (-35mm, -3.46875mm, 15.135mm)
  point Clamp_cbore_4-40_sketch142 = (35mm, -15.3125mm, 15.135mm)
  point Clamp_cbore_4-40_sketch143 = (-35mm, -15.3125mm, 15.135mm)
  point Clamp_cbore_4-40_sketch144 = (35mm, -27.15625mm, 15.135mm)
  point Clamp_cbore_4-40_sketch145 = (-35mm, -27.15625mm, 15.135mm)
  point Clamp_cbore_4-40_sketch146 = (35mm, -39mm, 15.135mm)
  point Clamp_cbore_4-40_sketch147 = (23.333333mm, -39mm, 15.135mm)
  point Clamp_cbore_4-40_sketch148 = (11.666667mm, -39mm, 15.135mm)
  point Clamp_cbore_4-40_sketch149 = (0mm, -39mm, 15.135mm)
  point Clamp_cbore_4-40_sketch150 = (-11.666667mm, -39mm, 15.135mm)
  point Clamp_cbore_4-40_sketch151 = (-23.333333mm, -39mm, 15.135mm)
  point Clamp_cbore_4-40_sketch152 = (-35mm, -39mm, 15.135mm)
  point Clamp_cbore_4-40_sketch153 = (35mm, 8.375mm, 15.135mm)
  point Clamp_cbore_4-40_sketch154 = (24mm, 8.375mm, 15.135mm)
  point Clamp_cbore_4-40_sketch155 = (12mm, 8.375mm, 15.135mm)
  point Clamp_cbore_4-40_sketch156 = (-12mm, 8.375mm, 15.135mm)
  point Clamp_cbore_4-40_sketch157 = (-24mm, 8.375mm, 15.135mm)
  point Clamp_cbore_4-40_sketch158 = (-35mm, 8.375mm, 15.135mm)
  point Clamp_cbore_4-40_sketch159 = (0mm, 0mm, 15.135mm)
  point Clamp_cbore_4-40_sketch160 = (35mm, -3.46875mm, 15.135mm)
  point Clamp_cbore_4-40_sketch161 = (-35mm, -3.46875mm, 15.135mm)
  point Clamp_cbore_4-40_sketch162 = (35mm, -15.3125mm, 15.135mm)
  point Clamp_cbore_4-40_sketch163 = (-35mm, -15.3125mm, 15.135mm)
  point Clamp_cbore_4-40_sketch164 = (35mm, -27.15625mm, 15.135mm)
  point Clamp_cbore_4-40_sketch165 = (-35mm, -27.15625mm, 15.135mm)
  point Clamp_cbore_4-40_sketch166 = (35mm, -39mm, 15.135mm)
  point Clamp_cbore_4-40_sketch167 = (23.333333mm, -39mm, 15.135mm)
  point Clamp_cbore_4-40_sketch168 = (11.666667mm, -39mm, 15.135mm)
  point Clamp_cbore_4-40_sketch169 = (0mm, -39mm, 15.135mm)
  point Clamp_cbore_4-40_sketch170 = (-11.666667mm, -39mm, 15.135mm)
  point Clamp_cbore_4-40_sketch171 = (-23.333333mm, -39mm, 15.135mm)
  point Clamp_cbore_4-40_sketch172 = (-35mm, -39mm, 15.135mm)
  point Clamp_cbore_4-40_sketch173 = (35mm, 8.375mm, 15.135mm)
  point Clamp_cbore_4-40_sketch174 = (24mm, 8.375mm, 15.135mm)
  point Clamp_cbore_4-40_sketch175 = (12mm, 8.375mm, 15.135mm)
  point Clamp_cbore_4-40_sketch176 = (-12mm, 8.375mm, 15.135mm)
  point Clamp_cbore_4-40_sketch177 = (-24mm, 8.375mm, 15.135mm)
  point Clamp_cbore_4-40_sketch178 = (-35mm, 8.375mm, 15.135mm)
  point Clamp_cbore_4-40_sketch179 = (0mm, 0mm, 15.135mm)
  point Clamp_cbore_4-40_sketch180 = (35mm, -3.46875mm, 15.135mm)
  point Clamp_cbore_4-40_sketch181 = (-35mm, -3.46875mm, 15.135mm)
  point Clamp_cbore_4-40_sketch182 = (35mm, -15.3125mm, 15.135mm)
  point Clamp_cbore_4-40_sketch183 = (-35mm, -15.3125mm, 15.135mm)
  point Clamp_cbore_4-40_sketch184 = (35mm, -27.15625mm, 15.135mm)
  point Clamp_cbore_4-40_sketch185 = (-35mm, -27.15625mm, 15.135mm)
  point Clamp_cbore_4-40_sketch186 = (35mm, -39mm, 15.135mm)
  point Clamp_cbore_4-40_sketch187 = (23.333333mm, -39mm, 15.135mm)
  point Clamp_cbore_4-40_sketch188 = (11.666667mm, -39mm, 15.135mm)
  point Clamp_cbore_4-40_sketch189 = (0mm, -39mm, 15.135mm)
  point Clamp_cbore_4-40_sketch190 = (-11.666667mm, -39mm, 15.135mm)
  point Clamp_cbore_4-40_sketch191 = (-23.333333mm, -39mm, 15.135mm)
  point Clamp_cbore_4-40_sketch192 = (-35mm, -39mm, 15.135mm)
  point Clamp_cbore_4-40_sketch193 = (35mm, 8.375mm, 15.135mm)
  point Clamp_cbore_4-40_sketch194 = (24mm, 8.375mm, 15.135mm)
  point Clamp_cbore_4-40_sketch195 = (12mm, 8.375mm, 15.135mm)
  point Clamp_cbore_4-40_sketch196 = (-12mm, 8.375mm, 15.135mm)
  point Clamp_cbore_4-40_sketch197 = (-24mm, 8.375mm, 15.135mm)
  point Clamp_cbore_4-40_sketch198 = (-35mm, 8.375mm, 15.135mm)
  point Clamp_cbore_4-40_sketch199 = (0mm, 0mm, 15.135mm)
  point Clamp_cbore_4-40_sketch200 = (35mm, -3.46875mm, 15.135mm)
  point Clamp_cbore_4-40_sketch201 = (-35mm, -3.46875mm, 15.135mm)
  point Clamp_cbore_4-40_sketch202 = (35mm, -15.3125mm, 15.135mm)
  point Clamp_cbore_4-40_sketch203 = (-35mm, -15.3125mm, 15.135mm)
  point Clamp_cbore_4-40_sketch204 = (35mm, -27.15625mm, 15.135mm)
  point Clamp_cbore_4-40_sketch205 = (-35mm, -27.15625mm, 15.135mm)
  point Clamp_cbore_4-40_sketch206 = (35mm, -39mm, 15.135mm)
  point Clamp_cbore_4-40_sketch207 = (23.333333mm, -39mm, 15.135mm)
  point Clamp_cbore_4-40_sketch208 = (11.666667mm, -39mm, 15.135mm)
  point Clamp_cbore_4-40_sketch209 = (0mm, -39mm, 15.135mm)
  point Clamp_cbore_4-40_sketch210 = (-11.666667mm, -39mm, 15.135mm)
  point Clamp_cbore_4-40_sketch211 = (-23.333333mm, -39mm, 15.135mm)
  point Clamp_cbore_4-40_sketch212 = (-35mm, -39mm, 15.135mm)
  point Clamp_cbore_4-40_sketch213 = (35mm, 8.375mm, 15.135mm)
  point Clamp_cbore_4-40_sketch214 = (24mm, 8.375mm, 15.135mm)
  point Clamp_cbore_4-40_sketch215 = (12mm, 8.375mm, 15.135mm)
  point Clamp_cbore_4-40_sketch216 = (-12mm, 8.375mm, 15.135mm)
  point Clamp_cbore_4-40_sketch217 = (-24mm, 8.375mm, 15.135mm)
  point Clamp_cbore_4-40_sketch218 = (-35mm, 8.375mm, 15.135mm)
  point Clamp_cbore_4-40_sketch219 = (0mm, 0mm, 15.135mm)
  point Clamp_cbore_4-40_sketch220 = (35mm, -3.46875mm, 15.135mm)
  point Clamp_cbore_4-40_sketch221 = (-35mm, -3.46875mm, 15.135mm)
  point Clamp_cbore_4-40_sketch222 = (35mm, -15.3125mm, 15.135mm)
  point Clamp_cbore_4-40_sketch223 = (-35mm, -15.3125mm, 15.135mm)
  point Clamp_cbore_4-40_sketch224 = (35mm, -27.15625mm, 15.135mm)
  point Clamp_cbore_4-40_sketch225 = (-35mm, -27.15625mm, 15.135mm)
  point Clamp_cbore_4-40_sketch226 = (35mm, -39mm, 15.135mm)
  point Clamp_cbore_4-40_sketch227 = (23.333333mm, -39mm, 15.135mm)
  point Clamp_cbore_4-40_sketch228 = (11.666667mm, -39mm, 15.135mm)
  point Clamp_cbore_4-40_sketch229 = (0mm, -39mm, 15.135mm)
  point Clamp_cbore_4-40_sketch230 = (-11.666667mm, -39mm, 15.135mm)
  point Clamp_cbore_4-40_sketch231 = (-23.333333mm, -39mm, 15.135mm)
  point Clamp_cbore_4-40_sketch232 = (-35mm, -39mm, 15.135mm)
  point Clamp_cbore_4-40_sketch233 = (35mm, 8.375mm, 15.135mm)
  point Clamp_cbore_4-40_sketch234 = (24mm, 8.375mm, 15.135mm)
  point Clamp_cbore_4-40_sketch235 = (12mm, 8.375mm, 15.135mm)
  point Clamp_cbore_4-40_sketch236 = (-12mm, 8.375mm, 15.135mm)
  point Clamp_cbore_4-40_sketch237 = (-24mm, 8.375mm, 15.135mm)
  point Clamp_cbore_4-40_sketch238 = (-35mm, 8.375mm, 15.135mm)
  point Clamp_cbore_4-40_sketch239 = (0mm, 0mm, 15.135mm)
  point Clamp_cbore_4-40_sketch240 = (35mm, -3.46875mm, 15.135mm)
  point Clamp_cbore_4-40_sketch241 = (-35mm, -3.46875mm, 15.135mm)
  point Clamp_cbore_4-40_sketch242 = (35mm, -15.3125mm, 15.135mm)
  point Clamp_cbore_4-40_sketch243 = (-35mm, -15.3125mm, 15.135mm)
  point Clamp_cbore_4-40_sketch244 = (35mm, -27.15625mm, 15.135mm)
  point Clamp_cbore_4-40_sketch245 = (-35mm, -27.15625mm, 15.135mm)
  point Clamp_cbore_4-40_sketch246 = (35mm, -39mm, 15.135mm)
  point Clamp_cbore_4-40_sketch247 = (23.333333mm, -39mm, 15.135mm)
  point Clamp_cbore_4-40_sketch248 = (11.666667mm, -39mm, 15.135mm)
  point Clamp_cbore_4-40_sketch249 = (0mm, -39mm, 15.135mm)
  point Clamp_cbore_4-40_sketch250 = (-11.666667mm, -39mm, 15.135mm)
  point Clamp_cbore_4-40_sketch251 = (-23.333333mm, -39mm, 15.135mm)
  point Clamp_cbore_4-40_sketch252 = (-35mm, -39mm, 15.135mm)
  point Clamp_cbore_4-40_sketch253 = (35mm, 8.375mm, 15.135mm)
  point Clamp_cbore_4-40_sketch254 = (24mm, 8.375mm, 15.135mm)
  point Clamp_cbore_4-40_sketch255 = (12mm, 8.375mm, 15.135mm)
  point Clamp_cbore_4-40_sketch256 = (-12mm, 8.375mm, 15.135mm)
  point Clamp_cbore_4-40_sketch257 = (-24mm, 8.375mm, 15.135mm)
  point Clamp_cbore_4-40_sketch258 = (-35mm, 8.375mm, 15.135mm)
  point Clamp_cbore_4-40_sketch259 = (0mm, 0mm, 15.135mm)
  point Clamp_cbore_4-40_sketch260 = (35mm, -3.46875mm, 15.135mm)
  point Clamp_cbore_4-40_sketch261 = (-35mm, -3.46875mm, 15.135mm)
  point Clamp_cbore_4-40_sketch262 = (35mm, -15.3125mm, 15.135mm)
  point Clamp_cbore_4-40_sketch263 = (-35mm, -15.3125mm, 15.135mm)
  point Clamp_cbore_4-40_sketch264 = (35mm, -27.15625mm, 15.135mm)
  point Clamp_cbore_4-40_sketch265 = (-35mm, -27.15625mm, 15.135mm)
  point Clamp_cbore_4-40_sketch266 = (35mm, -39mm, 15.135mm)
  point Clamp_cbore_4-40_sketch267 = (23.333333mm, -39mm, 15.135mm)
  point Clamp_cbore_4-40_sketch268 = (11.666667mm, -39mm, 15.135mm)
  point Clamp_cbore_4-40_sketch269 = (0mm, -39mm, 15.135mm)
  point Clamp_cbore_4-40_sketch270 = (-11.666667mm, -39mm, 15.135mm)
  point Clamp_cbore_4-40_sketch271 = (-23.333333mm, -39mm, 15.135mm)
  point Clamp_cbore_4-40_sketch272 = (-35mm, -39mm, 15.135mm)
  point Clamp_cbore_4-40_sketch273 = (35mm, 8.375mm, 15.135mm)
  point Clamp_cbore_4-40_sketch274 = (24mm, 8.375mm, 15.135mm)
  point Clamp_cbore_4-40_sketch275 = (12mm, 8.375mm, 15.135mm)
  point Clamp_cbore_4-40_sketch276 = (-12mm, 8.375mm, 15.135mm)
  point Clamp_cbore_4-40_sketch277 = (-24mm, 8.375mm, 15.135mm)
  point Clamp_cbore_4-40_sketch278 = (-35mm, 8.375mm, 15.135mm)
  point Clamp_cbore_4-40_sketch279 = (0mm, 0mm, 15.135mm)
  point Clamp_cbore_4-40_sketch280 = (35mm, -15.3125mm, 15.135mm)
  point Clamp_cbore_4-40_sketch281 = (-35mm, -15.3125mm, 15.135mm)
  point Clamp_cbore_4-40_sketch282 = (35mm, -39mm, 15.135mm)
  point Clamp_cbore_4-40_sketch283 = (0mm, -39mm, 15.135mm)
  point Clamp_cbore_4-40_sketch284 = (-35mm, -39mm, 15.135mm)
  point Clamp_cbore_4-40_sketch285 = (35mm, 8.375mm, 15.135mm)
  point Clamp_cbore_4-40_sketch286 = (12mm, 8.375mm, 15.135mm)
  point Clamp_cbore_4-40_sketch287 = (-12mm, 8.375mm, 15.135mm)
  point Clamp_cbore_4-40_sketch288 = (-35mm, 8.375mm, 15.135mm)
  point Clamp_cbore_4-40_sketch289 = (0mm, 0mm, 15.135mm)
  point Clamp_cbore_4-40_sketch290 = (35mm, -9.6275mm, 15.135mm)
  point Clamp_cbore_4-40_sketch291 = (-35mm, -9.6275mm, 15.135mm)
  point Clamp_cbore_4-40_sketch292 = (35mm, -27.63mm, 15.135mm)
  point Clamp_cbore_4-40_sketch293 = (0mm, -27.63mm, 15.135mm)
  point Clamp_cbore_4-40_sketch294 = (-35mm, -27.63mm, 15.135mm)
  point Clamp_cbore_4-40_sketch295 = (35mm, 8.375mm, 15.135mm)
  point Clamp_cbore_4-40_sketch296 = (12mm, 8.375mm, 15.135mm)
  point Clamp_cbore_4-40_sketch297 = (-12mm, 8.375mm, 15.135mm)
  point Clamp_cbore_4-40_sketch298 = (-35mm, 8.375mm, 15.135mm)
  point Clamp_cbore_4-40_sketch299 = (0mm, 0mm, 15.135mm)
  point Clamp_cbore_4-40_sketch300 = (35mm, -9.6275mm, 15.135mm)
  point Clamp_cbore_4-40_sketch301 = (-35mm, -9.6275mm, 15.135mm)
  point Clamp_cbore_4-40_sketch302 = (35mm, -27.63mm, 15.135mm)
  point Clamp_cbore_4-40_sketch303 = (0mm, -27.63mm, 15.135mm)
  point Clamp_cbore_4-40_sketch304 = (-35mm, -27.63mm, 15.135mm)
  point Clamp_cbore_4-40_sketch305 = (35mm, 8.375mm, 15.135mm)
  point Clamp_cbore_4-40_sketch306 = (12mm, 8.375mm, 15.135mm)
  point Clamp_cbore_4-40_sketch307 = (-12mm, 8.375mm, 15.135mm)
  point Clamp_cbore_4-40_sketch308 = (-35mm, 8.375mm, 15.135mm)
  point Clamp_cbore_4-40_sketch309 = (0mm, 0mm, 15.135mm)
  point Clamp_cbore_4-40_sketch310 = (35mm, -9.6275mm, 15.135mm)
  point Clamp_cbore_4-40_sketch311 = (-35mm, -9.6275mm, 15.135mm)
  point Clamp_cbore_4-40_sketch312 = (35mm, -27.63mm, 15.135mm)
  point Clamp_cbore_4-40_sketch313 = (0mm, -27.63mm, 15.135mm)
  point Clamp_cbore_4-40_sketch314 = (-35mm, -27.63mm, 15.135mm)
  point Clamp_cbore_4-40_sketch315 = (35mm, 8.375mm, 15.135mm)
  point Clamp_cbore_4-40_sketch316 = (12mm, 8.375mm, 15.135mm)
  point Clamp_cbore_4-40_sketch317 = (-12mm, 8.375mm, 15.135mm)
  point Clamp_cbore_4-40_sketch318 = (-35mm, 8.375mm, 15.135mm)
  point Clamp_cbore_4-40_sketch319 = (0mm, 0mm, 15.135mm)
  point Clamp_cbore_4-40_sketch320 = (35mm, -9.6275mm, 15.135mm)
  point Clamp_cbore_4-40_sketch321 = (-35mm, -9.6275mm, 15.135mm)
  point Clamp_cbore_4-40_sketch322 = (35mm, -27.63mm, 15.135mm)
  point Clamp_cbore_4-40_sketch323 = (0mm, -27.63mm, 15.135mm)
  point Clamp_cbore_4-40_sketch324 = (-35mm, -27.63mm, 15.135mm)
  point Clamp_cbore_4-40_sketch325 = (35mm, 8.375mm, 15.135mm)
  point Clamp_cbore_4-40_sketch326 = (12mm, 8.375mm, 15.135mm)
  point Clamp_cbore_4-40_sketch327 = (-12mm, 8.375mm, 15.135mm)
  point Clamp_cbore_4-40_sketch328 = (-35mm, 8.375mm, 15.135mm)
  point Clamp_cbore_4-40_sketch329 = (0mm, 0mm, 15.135mm)
  point Clamp_cbore_4-40_sketch330 = (35mm, -9.6275mm, 15.135mm)
  point Clamp_cbore_4-40_sketch331 = (-35mm, -9.6275mm, 15.135mm)
  point Clamp_cbore_4-40_sketch332 = (35mm, -27.63mm, 15.135mm)
  point Clamp_cbore_4-40_sketch333 = (0mm, -27.63mm, 15.135mm)
  point Clamp_cbore_4-40_sketch334 = (-35mm, -27.63mm, 15.135mm)
  point Clamp_cbore_4-40_sketch335 = (35mm, 8.375mm, 15.135mm)
  point Clamp_cbore_4-40_sketch336 = (12mm, 8.375mm, 15.135mm)
  point Clamp_cbore_4-40_sketch337 = (-12mm, 8.375mm, 15.135mm)
  point Clamp_cbore_4-40_sketch338 = (-35mm, 8.375mm, 15.135mm)
  point Clamp_cbore_4-40_sketch339 = (0mm, 0mm, 15.135mm)
  point Clamp_cbore_4-40_sketch340 = (35mm, -9.6275mm, 15.135mm)
  point Clamp_cbore_4-40_sketch341 = (-35mm, -9.6275mm, 15.135mm)
  point Clamp_cbore_4-40_sketch342 = (35mm, -27.63mm, 15.135mm)
  point Clamp_cbore_4-40_sketch343 = (0mm, -27.63mm, 15.135mm)
  point Clamp_cbore_4-40_sketch344 = (-35mm, -27.63mm, 15.135mm)
  point Clamp_cbore_4-40_sketch345 = (35mm, 8.375mm, 15.135mm)
  point Clamp_cbore_4-40_sketch346 = (12mm, 8.375mm, 15.135mm)
  point Clamp_cbore_4-40_sketch347 = (-12mm, 8.375mm, 15.135mm)
  point Clamp_cbore_4-40_sketch348 = (-35mm, 8.375mm, 15.135mm)
  point Clamp_cbore_4-40_sketch349 = (0mm, 0mm, 15.135mm)
  point Clamp_cbore_4-40_sketch350 = (35mm, -9.6275mm, 15.135mm)
  point Clamp_cbore_4-40_sketch351 = (-35mm, -9.6275mm, 15.135mm)
  point Clamp_cbore_4-40_sketch352 = (35mm, -27.63mm, 15.135mm)
  point Clamp_cbore_4-40_sketch353 = (0mm, -27.63mm, 15.135mm)
  point Clamp_cbore_4-40_sketch354 = (-35mm, -27.63mm, 15.135mm)
  point Clamp_cbore_4-40_sketch355 = (35mm, 8.375mm, 15.135mm)
  point Clamp_cbore_4-40_sketch356 = (12mm, 8.375mm, 15.135mm)
  point Clamp_cbore_4-40_sketch357 = (-12mm, 8.375mm, 15.135mm)
  point Clamp_cbore_4-40_sketch358 = (-35mm, 8.375mm, 15.135mm)
  point Clamp_cbore_4-40_sketch359 = (0mm, 0mm, 15.135mm)
  point Clamp_cbore_4-40_sketch360 = (35mm, -9.6275mm, 15.135mm)
  point Clamp_cbore_4-40_sketch361 = (-35mm, -9.6275mm, 15.135mm)
  point Clamp_cbore_4-40_sketch362 = (35mm, -27.63mm, 15.135mm)
  point Clamp_cbore_4-40_sketch363 = (0mm, -27.63mm, 15.135mm)
  point Clamp_cbore_4-40_sketch364 = (-35mm, -27.63mm, 15.135mm)
  point Clamp_cbore_4-40_sketch365 = (35mm, 8.375mm, 15.135mm)
  point Clamp_cbore_4-40_sketch366 = (12mm, 8.375mm, 15.135mm)
  point Clamp_cbore_4-40_sketch367 = (-12mm, 8.375mm, 15.135mm)
  point Clamp_cbore_4-40_sketch368 = (-35mm, 8.375mm, 15.135mm)
  point Clamp_cbore_4-40_sketch369 = (0mm, 0mm, 15.135mm)
  point Clamp_cbore_4-40_sketch370 = (35mm, -9.6275mm, 15.135mm)
  point Clamp_cbore_4-40_sketch371 = (-35mm, -9.6275mm, 15.135mm)
  point Clamp_cbore_4-40_sketch372 = (35mm, -27.63mm, 15.135mm)
  point Clamp_cbore_4-40_sketch373 = (0mm, -27.63mm, 15.135mm)
  point Clamp_cbore_4-40_sketch374 = (-35mm, -27.63mm, 15.135mm)
  point Clamp_cbore_4-40_sketch375 = (35mm, 8.375mm, 15.135mm)
  point Clamp_cbore_4-40_sketch376 = (12mm, 8.375mm, 15.135mm)
  point Clamp_cbore_4-40_sketch377 = (-12mm, 8.375mm, 15.135mm)
  point Clamp_cbore_4-40_sketch378 = (-35mm, 8.375mm, 15.135mm)
  point Clamp_cbore_4-40_sketch379 = (0mm, 0mm, 15.135mm)
  Solid1, Solid1_1 = imported_body(C:\Users\epm114\Documents\GitHub\Cavity work\coffin_4Q\inventor_files\coffin_4Q_hfss.stp)
  cavity [vacuum] = box(corner=(-40mm, -32.63mm, -15.135mm), size=(80mm, 45.38mm, 30.27mm))
  cavity.subtract(Solid1, Solid1_1)
  ro_pin_1 = cylinder(axis=Y, base_centre=($ro1_x, $y_front - $ro_pin_len, $ro1_z), radius=$pin_r, height=$ro_pin_len)
  ro_pin_2 = cylinder(axis=Y, base_centre=($ro2_x, $y_front - $ro_pin_len, $ro2_z), radius=$pin_r, height=$ro_pin_len)
  drive_pin_1 = cylinder(axis=Z, base_centre=($q1_x, -($cav_W/2 + $drive_dy_outer), $block_H/2 - $drive_pin_len), radius=$pin_r, height=$drive_pin_len)
  drive_pin_2 = cylinder(axis=Z, base_centre=($q2_x, -($cav_W/2 + $drive_dy_inner), $block_H/2 - $drive_pin_len), radius=$pin_r, height=$drive_pin_len)
  drive_pin_3 = cylinder(axis=Z, base_centre=($q3_x, -($cav_W/2 + $drive_dy_inner), $block_H/2 - $drive_pin_len), radius=$pin_r, height=$drive_pin_len)
  drive_pin_4 = cylinder(axis=Z, base_centre=($q4_x, -($cav_W/2 + $drive_dy_outer), $block_H/2 - $drive_pin_len), radius=$pin_r, height=$drive_pin_len)
  cavity.subtract(ro_pin_1, ro_pin_2, drive_pin_1..drive_pin_4)
  substrate_1 [sapphire] = box(corner=(-16.975mm, -18.13mm, -0.5mm), size=(2.45mm, 16.63mm, 0.43mm))
  pad_1a = rectangle(corner=(-15.85mm, -5.565mm, -0.07mm), x_size=0.2mm, y_size=4mm)
  lead_1a = rectangle(corner=(-15.765mm, -5.65mm, -0.07mm), x_size=0.03mm, y_size=0.085mm)
  pad_1b = rectangle(corner=(-15.85mm, -7.765mm, -0.07mm), x_size=0.2mm, y_size=2mm)
  lead_1b = rectangle(corner=(-15.765mm, -5.765mm, -0.07mm), x_size=0.03mm, y_size=0.085mm)
  pad_1a.unite(lead_1a)
  pad_1b.unite(lead_1b)
  jj_1 = rectangle(corner=(-15.765mm, -5.68mm, -0.07mm), x_size=0.03mm, y_size=0.03mm)
  jj_line_1 [non-model] = polyline((-15.75mm, -5.68mm, -0.07mm) (-15.75mm, -5.65mm, -0.07mm))
  substrate_2 [sapphire] = box(corner=(-6.475mm, -18.53mm, -0.5mm), size=(2.45mm, 16.63mm, 0.43mm))
  pad_2a = rectangle(corner=(-5.35mm, -5.965mm, -0.07mm), x_size=0.2mm, y_size=4mm)
  lead_2a = rectangle(corner=(-5.265mm, -6.05mm, -0.07mm), x_size=0.03mm, y_size=0.085mm)
  pad_2b = rectangle(corner=(-5.35mm, -8.165mm, -0.07mm), x_size=0.2mm, y_size=2mm)
  lead_2b = rectangle(corner=(-5.265mm, -6.165mm, -0.07mm), x_size=0.03mm, y_size=0.085mm)
  pad_2a.unite(lead_2a)
  pad_2b.unite(lead_2b)
  jj_2 = rectangle(corner=(-5.265mm, -6.08mm, -0.07mm), x_size=0.03mm, y_size=0.03mm)
  jj_line_2 [non-model] = polyline((-5.25mm, -6.08mm, -0.07mm) (-5.25mm, -6.05mm, -0.07mm))
  substrate_3 [sapphire] = box(corner=(4.025mm, -18.53mm, -0.5mm), size=(2.45mm, 16.63mm, 0.43mm))
  pad_3a = rectangle(corner=(5.15mm, -5.965mm, -0.07mm), x_size=0.2mm, y_size=4mm)
  lead_3a = rectangle(corner=(5.235mm, -6.05mm, -0.07mm), x_size=0.03mm, y_size=0.085mm)
  pad_3b = rectangle(corner=(5.15mm, -8.165mm, -0.07mm), x_size=0.2mm, y_size=2mm)
  lead_3b = rectangle(corner=(5.235mm, -6.165mm, -0.07mm), x_size=0.03mm, y_size=0.085mm)
  pad_3a.unite(lead_3a)
  pad_3b.unite(lead_3b)
  jj_3 = rectangle(corner=(5.235mm, -6.08mm, -0.07mm), x_size=0.03mm, y_size=0.03mm)
  jj_line_3 [non-model] = polyline((5.25mm, -6.08mm, -0.07mm) (5.25mm, -6.05mm, -0.07mm))
  substrate_4 [sapphire] = box(corner=(14.525mm, -18.13mm, -0.5mm), size=(2.45mm, 16.63mm, 0.43mm))
  pad_4a = rectangle(corner=(15.65mm, -5.565mm, -0.07mm), x_size=0.2mm, y_size=4mm)
  lead_4a = rectangle(corner=(15.735mm, -5.65mm, -0.07mm), x_size=0.03mm, y_size=0.085mm)
  pad_4b = rectangle(corner=(15.65mm, -7.765mm, -0.07mm), x_size=0.2mm, y_size=2mm)
  lead_4b = rectangle(corner=(15.735mm, -5.765mm, -0.07mm), x_size=0.03mm, y_size=0.085mm)
  pad_4a.unite(lead_4a)
  pad_4b.unite(lead_4b)
  jj_4 = rectangle(corner=(15.735mm, -5.68mm, -0.07mm), x_size=0.03mm, y_size=0.03mm)
  jj_line_4 [non-model] = polyline((15.75mm, -5.68mm, -0.07mm) (15.75mm, -5.65mm, -0.07mm))
boundaries and excitations:
  ro1: Impedance Faces=cavity.face(at (0, 12.75, -5)) Resistance=373.3629 Reactance=0
  ro2: Impedance Faces=cavity.face(at (0, 12.75, 5)) Resistance=373.3629 Reactance=0
  drive1: Impedance Faces=cavity.face(at (-15.75, -10, 15.135)) Resistance=373.3629 Reactance=0
  drive2: Impedance Faces=cavity.face(at (-5.25, -10.4, 15.135)) Resistance=373.3629 Reactance=0
  drive3: Impedance Faces=cavity.face(at (5.25, -10.4, 15.135)) Resistance=373.3629 Reactance=0
  drive4: Impedance Faces=cavity.face(at (15.75, -10, 15.135)) Resistance=373.3629 Reactance=0
  cryo_copper: Finite Conductivity Faces=cavity.face(at (5.25, -18.315, 0), at (-5.25, -18.315, 0), at (-15.75, -18.315, 0), at (0, 0, 10.135), at (-29.4142, -3.41421, 0), at (0, -4, 0), at (29.4142, -3.41421, 0), at (30, 0, 0), at (29.4142, 3.41421, 0), at (0, 4, 0), at (-29.4142, 3.41421, 0), at (-30, 0, 0)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) UseMaterial Material=cryo_copper IsInternal
  pads_1: Perfect E Objects=[pad_1a, pad_1b]
  jj1: Lumped RLC Objects=jj_1 CurrentLine{(-15.75, -5.68, -0.07) -> (-15.75, -5.65, -0.07)} RLC_Type=Parallel Inductance=Lj1
  pads_2: Perfect E Objects=[pad_2a, pad_2b]
  jj2: Lumped RLC Objects=jj_2 CurrentLine{(-5.25, -6.08, -0.07) -> (-5.25, -6.05, -0.07)} RLC_Type=Parallel Inductance=Lj2
  pads_3: Perfect E Objects=[pad_3a, pad_3b]
  jj3: Lumped RLC Objects=jj_3 CurrentLine{(5.25, -6.08, -0.07) -> (5.25, -6.05, -0.07)} RLC_Type=Parallel Inductance=Lj3
  pads_4: Perfect E Objects=[pad_4a, pad_4b]
  jj4: Lumped RLC Objects=jj_4 CurrentLine{(15.75, -5.68, -0.07) -> (15.75, -5.65, -0.07)} RLC_Type=Parallel Inductance=Lj4
mesh:
  tmon_substrate: LengthBased Objects=[substrate_1..substrate_4] MaxLength=0.5mm
  tmon_pads: LengthBased Objects=[pad_1a, pad_1b, pad_2a, pad_2b, pad_3a, pad_3b, pad_4a, pad_4b] MaxLength=50um
  tmon_jj: LengthBased Objects=[jj_1..jj_4] MaxLength=10um
setups:
  EM_Cavity_with_Transmons: HfssEigen MinimumFrequency=2GHz NumModes=12 MaxDeltaFreq=0.1 ConvergeOnRealFreq=true MaximumPasses=20 MinimumPasses=2 MinimumConvergedPasses=2 PercentRefinement=30 BasisOrder=-1
source amplitudes:
  #-10:1..#-10:8, #-10:10, #-10:11, #-10:12: 0 0
  #-10:9: 1 0
field plots:
  TM_MagE_mode12_XY: TM_MagE_mode12_XY over a plane on EM_Cavity_with_Transmons : LastAdaptive at Phase=0deg
  TM_MagE_mode5_XY: TM_MagE_mode5_XY over a plane on EM_Cavity_with_Transmons : LastAdaptive at Phase=0deg
  TM_MagE_mode6_XY: TM_MagE_mode6_XY over a plane on EM_Cavity_with_Transmons : LastAdaptive at Phase=0deg
  TM_MagE_mode7_XY: TM_MagE_mode7_XY over a plane on EM_Cavity_with_Transmons : LastAdaptive at Phase=0deg
  TM_MagE_mode8_XY: TM_MagE_mode8_XY over a plane on EM_Cavity_with_Transmons : LastAdaptive at Phase=0deg
  TM_MagE_mode1_XY: TM_MagE_mode1_XY over a plane on EM_Cavity_with_Transmons : LastAdaptive at Phase=0deg
  TM_MagE_mode2_XY: TM_MagE_mode2_XY over a plane on EM_Cavity_with_Transmons : LastAdaptive at Phase=0deg
  TM_MagE_mode3_XY: TM_MagE_mode3_XY over a plane on EM_Cavity_with_Transmons : LastAdaptive at Phase=0deg
  TM_MagE_mode4_XY: TM_MagE_mode4_XY over a plane on EM_Cavity_with_Transmons : LastAdaptive at Phase=0deg
reports:
  Eigen Modes Table 1: re(Mode(1)) vs Lj1 on EM_Cavity_with_Transmons : LastAdaptive
  Eigen Modes Plot 1: re(Mode(1)) vs Lj1 on EM_Cavity_with_Transmons : LastAdaptive
  Freq. vs. pass: re(Mode(1)), re(Mode(2)), re(Mode(3)), re(Mode(4)), re(Mode(5)), re(Mode(6)), re(Mode(7)), re(Mode(8)), re(Mode(9)), re(Mode(10)), re(Mode(11)), re(Mode(12)) vs Pass on EM_Cavity_with_Transmons : AdaptivePass [$block_H=30.27mm $block_L=80mm $bot_pocket_D=2.18mm $bot_pocket_L=10mm $cav_H=20.27mm $cav_L=60mm $cav_r=2mm $cav_W=8mm $chip_clear=0.05mm $chip_L=16.63mm $chip_slot_D=0.53mm $chip_slot_L=16.68mm $chip_slot_W=2.55mm $chip_T=0.5mm $chip_thk=0.43mm $chip_W=2.45mm $clamp_cbore_depth=3.2mm $clamp_cbore_dia=5.556mm $clamp_clear_dia=3.264mm $clamp_tap_depth=10mm $clamp_tap_drill=2.261mm $clamp_thread_depth=8mm $drive_dia=2.946mm $drive_dy=6.5mm $drive_dy_inner=6.4mm $drive_dy_outer=6mm $drive_flange_dx=3.81657mm $drive_flange_dy=3.81657mm $drive_pin_gap=2mm $hw_min_wall=1mm $indium_t=0.1mm $ovl=0.5mm $pin_r=0.635mm $q1_x=-15.75mm $q2_x=-5.25mm $q3_x=5.25mm $q4_x=15.75mm $q_pitch=10.5mm $q_pitch_max=10.5mm $ro1_x=0mm $ro1_z=-5mm $ro2_x=0mm $ro2_z=5mm $ro_dia=2.946mm $ro_pin_len=5mm $ro_port_len=8.75mm $sma_flange_T=1.57mm $sma_hole_spacing=10.795mm $sma_tap_depth=6.3mm $sma_tap_drill=1.778mm $sma_thread_depth=5.5mm $top_pocket_D=2.18mm $top_pocket_L=10mm $tunnel_L=18.63mm $tunnel_r=0mm $tunnel_W=3.45mm $wall_back=10mm $wall_x=10mm $wall_z=5mm $y_back=32.63mm $y_front=12.75mm Lj1=9.5nH Lj2=10.5nH Lj3=11.5nH Lj4=12.5nH]

design DM (HFSS, HFSS Modal Network, model units mm)
geometry:
  point Clamp_cbore_4-40_sketch = (35mm, -1.71875mm, 15.135mm)
  point Clamp_cbore_4-40_sketch1 = (-35mm, -1.71875mm, 15.135mm)
  point Clamp_cbore_4-40_sketch2 = (35mm, -15.3125mm, 15.135mm)
  point Clamp_cbore_4-40_sketch3 = (-35mm, -15.3125mm, 15.135mm)
  point Clamp_cbore_4-40_sketch4 = (35mm, -28.90625mm, 15.135mm)
  point Clamp_cbore_4-40_sketch5 = (-35mm, -28.90625mm, 15.135mm)
  point Clamp_cbore_4-40_sketch6 = (35mm, -42.5mm, 15.135mm)
  point Clamp_cbore_4-40_sketch7 = (23.333333mm, -42.5mm, 15.135mm)
  point Clamp_cbore_4-40_sketch8 = (11.666667mm, -42.5mm, 15.135mm)
  point Clamp_cbore_4-40_sketch9 = (0mm, -42.5mm, 15.135mm)
  point Clamp_cbore_4-40_sketch10 = (-11.666667mm, -42.5mm, 15.135mm)
  point Clamp_cbore_4-40_sketch11 = (-23.333333mm, -42.5mm, 15.135mm)
  point Clamp_cbore_4-40_sketch12 = (-35mm, -42.5mm, 15.135mm)
  point Clamp_cbore_4-40_sketch13 = (35mm, 11.875mm, 15.135mm)
  point Clamp_cbore_4-40_sketch14 = (24mm, 11.875mm, 15.135mm)
  point Clamp_cbore_4-40_sketch15 = (12mm, 11.875mm, 15.135mm)
  point Clamp_cbore_4-40_sketch16 = (-12mm, 11.875mm, 15.135mm)
  point Clamp_cbore_4-40_sketch17 = (-24mm, 11.875mm, 15.135mm)
  point Clamp_cbore_4-40_sketch18 = (-35mm, 11.875mm, 15.135mm)
  point Clamp_cbore_4-40_sketch19 = (0mm, 0mm, 15.135mm)
  point Clamp_cbore_4-40_sketch20 = (35mm, -1.71875mm, 15.135mm)
  point Clamp_cbore_4-40_sketch21 = (-35mm, -1.71875mm, 15.135mm)
  point Clamp_cbore_4-40_sketch22 = (35mm, -15.3125mm, 15.135mm)
  point Clamp_cbore_4-40_sketch23 = (-35mm, -15.3125mm, 15.135mm)
  point Clamp_cbore_4-40_sketch24 = (35mm, -28.90625mm, 15.135mm)
  point Clamp_cbore_4-40_sketch25 = (-35mm, -28.90625mm, 15.135mm)
  point Clamp_cbore_4-40_sketch26 = (35mm, -42.5mm, 15.135mm)
  point Clamp_cbore_4-40_sketch27 = (23.333333mm, -42.5mm, 15.135mm)
  point Clamp_cbore_4-40_sketch28 = (11.666667mm, -42.5mm, 15.135mm)
  point Clamp_cbore_4-40_sketch29 = (0mm, -42.5mm, 15.135mm)
  point Clamp_cbore_4-40_sketch30 = (-11.666667mm, -42.5mm, 15.135mm)
  point Clamp_cbore_4-40_sketch31 = (-23.333333mm, -42.5mm, 15.135mm)
  point Clamp_cbore_4-40_sketch32 = (-35mm, -42.5mm, 15.135mm)
  point Clamp_cbore_4-40_sketch33 = (35mm, 11.875mm, 15.135mm)
  point Clamp_cbore_4-40_sketch34 = (24mm, 11.875mm, 15.135mm)
  point Clamp_cbore_4-40_sketch35 = (12mm, 11.875mm, 15.135mm)
  point Clamp_cbore_4-40_sketch36 = (-12mm, 11.875mm, 15.135mm)
  point Clamp_cbore_4-40_sketch37 = (-24mm, 11.875mm, 15.135mm)
  point Clamp_cbore_4-40_sketch38 = (-35mm, 11.875mm, 15.135mm)
  point Clamp_cbore_4-40_sketch39 = (0mm, 0mm, 15.135mm)
  point Clamp_cbore_4-40_sketch40 = (35mm, -3.46875mm, 15.135mm)
  point Clamp_cbore_4-40_sketch41 = (-35mm, -3.46875mm, 15.135mm)
  point Clamp_cbore_4-40_sketch42 = (35mm, -15.3125mm, 15.135mm)
  point Clamp_cbore_4-40_sketch43 = (-35mm, -15.3125mm, 15.135mm)
  point Clamp_cbore_4-40_sketch44 = (35mm, -27.15625mm, 15.135mm)
  point Clamp_cbore_4-40_sketch45 = (-35mm, -27.15625mm, 15.135mm)
  point Clamp_cbore_4-40_sketch46 = (35mm, -39mm, 15.135mm)
  point Clamp_cbore_4-40_sketch47 = (23.333333mm, -39mm, 15.135mm)
  point Clamp_cbore_4-40_sketch48 = (11.666667mm, -39mm, 15.135mm)
  point Clamp_cbore_4-40_sketch49 = (0mm, -39mm, 15.135mm)
  point Clamp_cbore_4-40_sketch50 = (-11.666667mm, -39mm, 15.135mm)
  point Clamp_cbore_4-40_sketch51 = (-23.333333mm, -39mm, 15.135mm)
  point Clamp_cbore_4-40_sketch52 = (-35mm, -39mm, 15.135mm)
  point Clamp_cbore_4-40_sketch53 = (35mm, 8.375mm, 15.135mm)
  point Clamp_cbore_4-40_sketch54 = (24mm, 8.375mm, 15.135mm)
  point Clamp_cbore_4-40_sketch55 = (12mm, 8.375mm, 15.135mm)
  point Clamp_cbore_4-40_sketch56 = (-12mm, 8.375mm, 15.135mm)
  point Clamp_cbore_4-40_sketch57 = (-24mm, 8.375mm, 15.135mm)
  point Clamp_cbore_4-40_sketch58 = (-35mm, 8.375mm, 15.135mm)
  point Clamp_cbore_4-40_sketch59 = (0mm, 0mm, 15.135mm)
  point Clamp_cbore_4-40_sketch60 = (35mm, -3.46875mm, 15.135mm)
  point Clamp_cbore_4-40_sketch61 = (-35mm, -3.46875mm, 15.135mm)
  point Clamp_cbore_4-40_sketch62 = (35mm, -15.3125mm, 15.135mm)
  point Clamp_cbore_4-40_sketch63 = (-35mm, -15.3125mm, 15.135mm)
  point Clamp_cbore_4-40_sketch64 = (35mm, -27.15625mm, 15.135mm)
  point Clamp_cbore_4-40_sketch65 = (-35mm, -27.15625mm, 15.135mm)
  point Clamp_cbore_4-40_sketch66 = (35mm, -39mm, 15.135mm)
  point Clamp_cbore_4-40_sketch67 = (23.333333mm, -39mm, 15.135mm)
  point Clamp_cbore_4-40_sketch68 = (11.666667mm, -39mm, 15.135mm)
  point Clamp_cbore_4-40_sketch69 = (0mm, -39mm, 15.135mm)
  point Clamp_cbore_4-40_sketch70 = (-11.666667mm, -39mm, 15.135mm)
  point Clamp_cbore_4-40_sketch71 = (-23.333333mm, -39mm, 15.135mm)
  point Clamp_cbore_4-40_sketch72 = (-35mm, -39mm, 15.135mm)
  point Clamp_cbore_4-40_sketch73 = (35mm, 8.375mm, 15.135mm)
  point Clamp_cbore_4-40_sketch74 = (24mm, 8.375mm, 15.135mm)
  point Clamp_cbore_4-40_sketch75 = (12mm, 8.375mm, 15.135mm)
  point Clamp_cbore_4-40_sketch76 = (-12mm, 8.375mm, 15.135mm)
  point Clamp_cbore_4-40_sketch77 = (-24mm, 8.375mm, 15.135mm)
  point Clamp_cbore_4-40_sketch78 = (-35mm, 8.375mm, 15.135mm)
  point Clamp_cbore_4-40_sketch79 = (0mm, 0mm, 15.135mm)
  point Clamp_cbore_4-40_sketch80 = (35mm, -15.3125mm, 15.135mm)
  point Clamp_cbore_4-40_sketch81 = (-35mm, -15.3125mm, 15.135mm)
  point Clamp_cbore_4-40_sketch82 = (35mm, -39mm, 15.135mm)
  point Clamp_cbore_4-40_sketch83 = (0mm, -39mm, 15.135mm)
  point Clamp_cbore_4-40_sketch84 = (-35mm, -39mm, 15.135mm)
  point Clamp_cbore_4-40_sketch85 = (35mm, 8.375mm, 15.135mm)
  point Clamp_cbore_4-40_sketch86 = (12mm, 8.375mm, 15.135mm)
  point Clamp_cbore_4-40_sketch87 = (-12mm, 8.375mm, 15.135mm)
  point Clamp_cbore_4-40_sketch88 = (-35mm, 8.375mm, 15.135mm)
  point Clamp_cbore_4-40_sketch89 = (0mm, 0mm, 15.135mm)
  point Clamp_cbore_4-40_sketch90 = (35mm, -9.6275mm, 15.135mm)
  point Clamp_cbore_4-40_sketch91 = (-35mm, -9.6275mm, 15.135mm)
  point Clamp_cbore_4-40_sketch92 = (35mm, -27.63mm, 15.135mm)
  point Clamp_cbore_4-40_sketch93 = (0mm, -27.63mm, 15.135mm)
  point Clamp_cbore_4-40_sketch94 = (-35mm, -27.63mm, 15.135mm)
  point Clamp_cbore_4-40_sketch95 = (35mm, 8.375mm, 15.135mm)
  point Clamp_cbore_4-40_sketch96 = (12mm, 8.375mm, 15.135mm)
  point Clamp_cbore_4-40_sketch97 = (-12mm, 8.375mm, 15.135mm)
  point Clamp_cbore_4-40_sketch98 = (-35mm, 8.375mm, 15.135mm)
  point Clamp_cbore_4-40_sketch99 = (0mm, 0mm, 15.135mm)
  Solid1, Solid1_1 = imported_body(C:\Users\epm114\Documents\GitHub\Cavity work\coffin_4Q\inventor_files\coffin_4Q_hfss.stp)
  cavity [vacuum] = box(corner=(-40mm, -32.63mm, -15.135mm), size=(80mm, 45.38mm, 30.27mm))
  cavity.subtract(Solid1, Solid1_1)
  ro_pin_1 = cylinder(axis=Y, base_centre=($ro1_x, $y_front - $ro_pin_len, $ro1_z), radius=$pin_r, height=$ro_pin_len)
  ro_pin_2 = cylinder(axis=Y, base_centre=($ro2_x, $y_front - $ro_pin_len, $ro2_z), radius=$pin_r, height=$ro_pin_len)
  drive_pin_1 = cylinder(axis=Z, base_centre=($q1_x, -($cav_W/2 + $drive_dy_outer), $block_H/2 - $drive_pin_len), radius=$pin_r, height=$drive_pin_len)
  drive_pin_2 = cylinder(axis=Z, base_centre=($q2_x, -($cav_W/2 + $drive_dy_inner), $block_H/2 - $drive_pin_len), radius=$pin_r, height=$drive_pin_len)
  drive_pin_3 = cylinder(axis=Z, base_centre=($q3_x, -($cav_W/2 + $drive_dy_inner), $block_H/2 - $drive_pin_len), radius=$pin_r, height=$drive_pin_len)
  drive_pin_4 = cylinder(axis=Z, base_centre=($q4_x, -($cav_W/2 + $drive_dy_outer), $block_H/2 - $drive_pin_len), radius=$pin_r, height=$drive_pin_len)
  cavity.subtract(ro_pin_1, ro_pin_2, drive_pin_1..drive_pin_4)
  substrate_1 [sapphire] = box(corner=(-16.975mm, -18.13mm, -0.5mm), size=(2.45mm, 16.63mm, 0.43mm))
  pad_1a = rectangle(corner=(-15.85mm, -5.565mm, -0.07mm), x_size=0.2mm, y_size=4mm)
  lead_1a = rectangle(corner=(-15.765mm, -5.65mm, -0.07mm), x_size=0.03mm, y_size=0.085mm)
  pad_1b = rectangle(corner=(-15.85mm, -7.765mm, -0.07mm), x_size=0.2mm, y_size=2mm)
  lead_1b = rectangle(corner=(-15.765mm, -5.765mm, -0.07mm), x_size=0.03mm, y_size=0.085mm)
  pad_1a.unite(lead_1a)
  pad_1b.unite(lead_1b)
  jj_1 = rectangle(corner=(-15.765mm, -5.68mm, -0.07mm), x_size=0.03mm, y_size=0.03mm)
  jj_line_1 [non-model] = polyline((-15.75mm, -5.68mm, -0.07mm) (-15.75mm, -5.65mm, -0.07mm))
  substrate_2 [sapphire] = box(corner=(-6.475mm, -18.53mm, -0.5mm), size=(2.45mm, 16.63mm, 0.43mm))
  pad_2a = rectangle(corner=(-5.35mm, -5.965mm, -0.07mm), x_size=0.2mm, y_size=4mm)
  lead_2a = rectangle(corner=(-5.265mm, -6.05mm, -0.07mm), x_size=0.03mm, y_size=0.085mm)
  pad_2b = rectangle(corner=(-5.35mm, -8.165mm, -0.07mm), x_size=0.2mm, y_size=2mm)
  lead_2b = rectangle(corner=(-5.265mm, -6.165mm, -0.07mm), x_size=0.03mm, y_size=0.085mm)
  pad_2a.unite(lead_2a)
  pad_2b.unite(lead_2b)
  jj_2 = rectangle(corner=(-5.265mm, -6.08mm, -0.07mm), x_size=0.03mm, y_size=0.03mm)
  jj_line_2 [non-model] = polyline((-5.25mm, -6.08mm, -0.07mm) (-5.25mm, -6.05mm, -0.07mm))
  substrate_3 [sapphire] = box(corner=(4.025mm, -18.53mm, -0.5mm), size=(2.45mm, 16.63mm, 0.43mm))
  pad_3a = rectangle(corner=(5.15mm, -5.965mm, -0.07mm), x_size=0.2mm, y_size=4mm)
  lead_3a = rectangle(corner=(5.235mm, -6.05mm, -0.07mm), x_size=0.03mm, y_size=0.085mm)
  pad_3b = rectangle(corner=(5.15mm, -8.165mm, -0.07mm), x_size=0.2mm, y_size=2mm)
  lead_3b = rectangle(corner=(5.235mm, -6.165mm, -0.07mm), x_size=0.03mm, y_size=0.085mm)
  pad_3a.unite(lead_3a)
  pad_3b.unite(lead_3b)
  jj_3 = rectangle(corner=(5.235mm, -6.08mm, -0.07mm), x_size=0.03mm, y_size=0.03mm)
  jj_line_3 [non-model] = polyline((5.25mm, -6.08mm, -0.07mm) (5.25mm, -6.05mm, -0.07mm))
  substrate_4 [sapphire] = box(corner=(14.525mm, -18.13mm, -0.5mm), size=(2.45mm, 16.63mm, 0.43mm))
  pad_4a = rectangle(corner=(15.65mm, -5.565mm, -0.07mm), x_size=0.2mm, y_size=4mm)
  lead_4a = rectangle(corner=(15.735mm, -5.65mm, -0.07mm), x_size=0.03mm, y_size=0.085mm)
  pad_4b = rectangle(corner=(15.65mm, -7.765mm, -0.07mm), x_size=0.2mm, y_size=2mm)
  lead_4b = rectangle(corner=(15.735mm, -5.765mm, -0.07mm), x_size=0.03mm, y_size=0.085mm)
  pad_4a.unite(lead_4a)
  pad_4b.unite(lead_4b)
  jj_4 = rectangle(corner=(15.735mm, -5.68mm, -0.07mm), x_size=0.03mm, y_size=0.03mm)
  jj_line_4 [non-model] = polyline((15.75mm, -5.68mm, -0.07mm) (15.75mm, -5.65mm, -0.07mm))
boundaries and excitations:
  ro1: Impedance Faces=cavity.face(at (0, 12.75, -5)) Resistance=373.3629 Reactance=0
  ro2: Impedance Faces=cavity.face(at (0, 12.75, 5)) Resistance=373.3629 Reactance=0
  drive1: Impedance Faces=cavity.face(at (-15.75, -10, 15.135)) Resistance=373.3629 Reactance=0
  drive2: Impedance Faces=cavity.face(at (-5.25, -10.4, 15.135)) Resistance=373.3629 Reactance=0
  drive3: Impedance Faces=cavity.face(at (5.25, -10.4, 15.135)) Resistance=373.3629 Reactance=0
  drive4: Impedance Faces=cavity.face(at (15.75, -10, 15.135)) Resistance=373.3629 Reactance=0
  cryo_copper: Finite Conductivity Faces=cavity.face(at (5.25, -18.315, 0), at (-5.25, -18.315, 0), at (-15.75, -18.315, 0), at (0, 0, 10.135), at (-29.4142, -3.41421, 0), at (0, -4, 0), at (29.4142, -3.41421, 0), at (30, 0, 0), at (29.4142, 3.41421, 0), at (0, 4, 0), at (-29.4142, 3.41421, 0), at (-30, 0, 0)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) UseMaterial Material=cryo_copper IsInternal
  pads_1: Perfect E Objects=[pad_1a, pad_1b]
  pads_2: Perfect E Objects=[pad_2a, pad_2b]
  pads_3: Perfect E Objects=[pad_3a, pad_3b]
  pads_4: Perfect E Objects=[pad_4a, pad_4b]
  jj1: Lumped Port Objects=jj_1 LumpedPortType=Modal Modes{Mode1{IntLine{(-15.75, -5.68, -0.07) -> (-15.75, -5.65, -0.07)} CharImp=Zpi}} Impedance=1000000ohm
  jj2: Lumped Port Objects=jj_2 LumpedPortType=Modal Modes{Mode1{IntLine{(-5.25, -6.08, -0.07) -> (-5.25, -6.05, -0.07)} CharImp=Zpi}} Impedance=1000000ohm
  jj3: Lumped Port Objects=jj_3 LumpedPortType=Modal Modes{Mode1{IntLine{(5.25, -6.08, -0.07) -> (5.25, -6.05, -0.07)} CharImp=Zpi}} Impedance=1000000ohm
  jj4: Lumped Port Objects=jj_4 LumpedPortType=Modal Modes{Mode1{IntLine{(15.75, -5.68, -0.07) -> (15.75, -5.65, -0.07)} CharImp=Zpi}} Impedance=1000000ohm
mesh:
  tmon_substrate: LengthBased Objects=[substrate_1..substrate_4] MaxLength=0.5mm
  tmon_pads: LengthBased Objects=[pad_1a, pad_1b, pad_2a, pad_2b, pad_3a, pad_3b, pad_4a, pad_4b] MaxLength=50um
  tmon_jj: LengthBased Objects=[jj_1..jj_4] MaxLength=10um
setups:
  DM: HfssDriven Frequency=4.5GHz MaxDeltaS=0.01 MaximumPasses=10 MinimumPasses=3 MinimumConvergedPasses=3 PercentRefinement=30 BasisOrder=-1 PortAccuracy=2 DrivenSolverType="Direct Solver"
    sweep Sweep_000: 3GHz to 3.1GHz, 10000 points; Type=Fast
    sweep Sweep_001: 3.1GHz to 3.2GHz, 10000 points; Type=Fast
    sweep Sweep_002: 3.2GHz to 3.3GHz, 10000 points; Type=Fast
    sweep Sweep_003: 3.3GHz to 3.4GHz, 10000 points; Type=Fast
    sweep Sweep_004: 3.4GHz to 3.5GHz, 10000 points; Type=Fast
    sweep Sweep_005: 3.5GHz to 3.6GHz, 10000 points; Type=Fast
    sweep Sweep_006: 3.6GHz to 3.7GHz, 10000 points; Type=Fast
    sweep Sweep_007: 3.7GHz to 3.8GHz, 10000 points; Type=Fast
    sweep Sweep_008: 3.8GHz to 3.9GHz, 10000 points; Type=Fast
    sweep Sweep_009: 3.9GHz to 4GHz, 10000 points; Type=Fast
    sweep Sweep_010: 4GHz to 4.1GHz, 10000 points; Type=Fast
    sweep Sweep_011: 4.1GHz to 4.2GHz, 10000 points; Type=Fast
    sweep Sweep_012: 4.2GHz to 4.3GHz, 10000 points; Type=Fast
    sweep Sweep_013: 4.3GHz to 4.4GHz, 10000 points; Type=Fast
    sweep Sweep_014: 4.4GHz to 4.5GHz, 10000 points; Type=Fast
    sweep Sweep_015: 4.5GHz to 4.6GHz, 10000 points; Type=Fast
    sweep Sweep_016: 4.6GHz to 4.7GHz, 10000 points; Type=Fast
    sweep Sweep_017: 4.7GHz to 4.8GHz, 10000 points; Type=Fast
    sweep Sweep_018: 4.8GHz to 4.9GHz, 10000 points; Type=Fast
    sweep Sweep_019: 4.9GHz to 5GHz, 10000 points; Type=Fast
    sweep Sweep_020: 5GHz to 5.1GHz, 10000 points; Type=Fast
    sweep Sweep_021: 5.1GHz to 5.2GHz, 10000 points; Type=Fast
    sweep Sweep_022: 5.2GHz to 5.3GHz, 10000 points; Type=Fast
    sweep Sweep_023: 5.3GHz to 5.4GHz, 10000 points; Type=Fast
    sweep Sweep_024: 5.4GHz to 5.5GHz, 10000 points; Type=Fast
    sweep Sweep_025: 5.5GHz to 5.6GHz, 10000 points; Type=Fast
    sweep Sweep_026: 5.6GHz to 5.7GHz, 10000 points; Type=Fast
    sweep Sweep_027: 5.7GHz to 5.8GHz, 10000 points; Type=Fast
    sweep Sweep_028: 5.8GHz to 5.9GHz, 10000 points; Type=Fast
    sweep Sweep_029: 5.9GHz to 6GHz, 10000 points; Type=Fast
    sweep Sweep_030: 6GHz to 6.1GHz, 10000 points; Type=Fast
    sweep Sweep_031: 6.1GHz to 6.2GHz, 10000 points; Type=Fast
    sweep Sweep_032: 6.2GHz to 6.3GHz, 10000 points; Type=Fast
    sweep Sweep_033: 6.3GHz to 6.4GHz, 10000 points; Type=Fast
    sweep Sweep_034: 6.4GHz to 6.5GHz, 10000 points; Type=Fast
    sweep Sweep_035: 6.5GHz to 6.6GHz, 10000 points; Type=Fast
    sweep Sweep_036: 6.6GHz to 6.7GHz, 10000 points; Type=Fast
    sweep Sweep_037: 6.7GHz to 6.8GHz, 10000 points; Type=Fast
    sweep Sweep_038: 6.8GHz to 6.9GHz, 10000 points; Type=Fast
    sweep Sweep_039: 6.9GHz to 7GHz, 10000 points; Type=Fast
    sweep Sweep_040: 7GHz to 7.1GHz, 10000 points; Type=Fast
    sweep Sweep_041: 7.1GHz to 7.2GHz, 10000 points; Type=Fast
    sweep Sweep_042: 7.2GHz to 7.3GHz, 10000 points; Type=Fast
    sweep Sweep_043: 7.3GHz to 7.4GHz, 10000 points; Type=Fast
    sweep Sweep_044: 7.4GHz to 7.5GHz, 10000 points; Type=Fast
    sweep Sweep_045: 7.5GHz to 7.6GHz, 10000 points; Type=Fast
    sweep Sweep_046: 7.6GHz to 7.7GHz, 10000 points; Type=Fast
    sweep Sweep_047: 7.7GHz to 7.8GHz, 10000 points; Type=Fast
    sweep Sweep_048: 7.8GHz to 7.9GHz, 10000 points; Type=Fast
    sweep Sweep_049: 7.9GHz to 8GHz, 10000 points; Type=Fast
    sweep Sweep_050: 8GHz to 8.1GHz, 10000 points; Type=Fast
    sweep Sweep_051: 8.1GHz to 8.2GHz, 10000 points; Type=Fast
    sweep Sweep_052: 8.2GHz to 8.3GHz, 10000 points; Type=Fast
    sweep Sweep_053: 8.3GHz to 8.4GHz, 10000 points; Type=Fast
    sweep Sweep_054: 8.4GHz to 8.5GHz, 10000 points; Type=Fast
    sweep Sweep_055: 8.5GHz to 8.6GHz, 10000 points; Type=Fast
    sweep Sweep_056: 8.6GHz to 8.7GHz, 10000 points; Type=Fast
    sweep Sweep_057: 8.7GHz to 8.8GHz, 10000 points; Type=Fast
    sweep Sweep_058: 8.8GHz to 8.9GHz, 10000 points; Type=Fast
    sweep Sweep_059: 8.9GHz to 9GHz, 10000 points; Type=Fast
    sweep Sweep_060: 9GHz to 9.1GHz, 10000 points; Type=Fast
    sweep Sweep_061: 9.1GHz to 9.2GHz, 10000 points; Type=Fast
    sweep Sweep_062: 9.2GHz to 9.3GHz, 10000 points; Type=Fast
    sweep Sweep_063: 9.3GHz to 9.4GHz, 10000 points; Type=Fast
    sweep Sweep_064: 9.4GHz to 9.5GHz, 10000 points; Type=Fast
    sweep Sweep_065: 9.5GHz to 9.6GHz, 10000 points; Type=Fast
    sweep Sweep_066: 9.6GHz to 9.7GHz, 10000 points; Type=Fast
    sweep Sweep_067: 9.7GHz to 9.8GHz, 10000 points; Type=Fast
    sweep Sweep_068: 9.8GHz to 9.9GHz, 10000 points; Type=Fast
    sweep Sweep_069: 9.9GHz to 10GHz, 10000 points; Type=Fast
source amplitudes:
  jj1:1: 1W 0deg
  jj2:1, jj3:1, jj4:1: 0W 0deg

design DM_1port_Q1 (HFSS, HFSS Modal Network, model units mm)
variables:
  Lj2 = 10.5nH
  Lj3 = 11.5nH
  Lj4 = 12.5nH
geometry:
  point Clamp_cbore_4-40_sketch = (35mm, -1.71875mm, 15.135mm)
  point Clamp_cbore_4-40_sketch1 = (-35mm, -1.71875mm, 15.135mm)
  point Clamp_cbore_4-40_sketch2 = (35mm, -15.3125mm, 15.135mm)
  point Clamp_cbore_4-40_sketch3 = (-35mm, -15.3125mm, 15.135mm)
  point Clamp_cbore_4-40_sketch4 = (35mm, -28.90625mm, 15.135mm)
  point Clamp_cbore_4-40_sketch5 = (-35mm, -28.90625mm, 15.135mm)
  point Clamp_cbore_4-40_sketch6 = (35mm, -42.5mm, 15.135mm)
  point Clamp_cbore_4-40_sketch7 = (23.333333mm, -42.5mm, 15.135mm)
  point Clamp_cbore_4-40_sketch8 = (11.666667mm, -42.5mm, 15.135mm)
  point Clamp_cbore_4-40_sketch9 = (0mm, -42.5mm, 15.135mm)
  point Clamp_cbore_4-40_sketch10 = (-11.666667mm, -42.5mm, 15.135mm)
  point Clamp_cbore_4-40_sketch11 = (-23.333333mm, -42.5mm, 15.135mm)
  point Clamp_cbore_4-40_sketch12 = (-35mm, -42.5mm, 15.135mm)
  point Clamp_cbore_4-40_sketch13 = (35mm, 11.875mm, 15.135mm)
  point Clamp_cbore_4-40_sketch14 = (24mm, 11.875mm, 15.135mm)
  point Clamp_cbore_4-40_sketch15 = (12mm, 11.875mm, 15.135mm)
  point Clamp_cbore_4-40_sketch16 = (-12mm, 11.875mm, 15.135mm)
  point Clamp_cbore_4-40_sketch17 = (-24mm, 11.875mm, 15.135mm)
  point Clamp_cbore_4-40_sketch18 = (-35mm, 11.875mm, 15.135mm)
  point Clamp_cbore_4-40_sketch19 = (0mm, 0mm, 15.135mm)
  point Clamp_cbore_4-40_sketch20 = (35mm, -1.71875mm, 15.135mm)
  point Clamp_cbore_4-40_sketch21 = (-35mm, -1.71875mm, 15.135mm)
  point Clamp_cbore_4-40_sketch22 = (35mm, -15.3125mm, 15.135mm)
  point Clamp_cbore_4-40_sketch23 = (-35mm, -15.3125mm, 15.135mm)
  point Clamp_cbore_4-40_sketch24 = (35mm, -28.90625mm, 15.135mm)
  point Clamp_cbore_4-40_sketch25 = (-35mm, -28.90625mm, 15.135mm)
  point Clamp_cbore_4-40_sketch26 = (35mm, -42.5mm, 15.135mm)
  point Clamp_cbore_4-40_sketch27 = (23.333333mm, -42.5mm, 15.135mm)
  point Clamp_cbore_4-40_sketch28 = (11.666667mm, -42.5mm, 15.135mm)
  point Clamp_cbore_4-40_sketch29 = (0mm, -42.5mm, 15.135mm)
  point Clamp_cbore_4-40_sketch30 = (-11.666667mm, -42.5mm, 15.135mm)
  point Clamp_cbore_4-40_sketch31 = (-23.333333mm, -42.5mm, 15.135mm)
  point Clamp_cbore_4-40_sketch32 = (-35mm, -42.5mm, 15.135mm)
  point Clamp_cbore_4-40_sketch33 = (35mm, 11.875mm, 15.135mm)
  point Clamp_cbore_4-40_sketch34 = (24mm, 11.875mm, 15.135mm)
  point Clamp_cbore_4-40_sketch35 = (12mm, 11.875mm, 15.135mm)
  point Clamp_cbore_4-40_sketch36 = (-12mm, 11.875mm, 15.135mm)
  point Clamp_cbore_4-40_sketch37 = (-24mm, 11.875mm, 15.135mm)
  point Clamp_cbore_4-40_sketch38 = (-35mm, 11.875mm, 15.135mm)
  point Clamp_cbore_4-40_sketch39 = (0mm, 0mm, 15.135mm)
  point Clamp_cbore_4-40_sketch40 = (35mm, -3.46875mm, 15.135mm)
  point Clamp_cbore_4-40_sketch41 = (-35mm, -3.46875mm, 15.135mm)
  point Clamp_cbore_4-40_sketch42 = (35mm, -15.3125mm, 15.135mm)
  point Clamp_cbore_4-40_sketch43 = (-35mm, -15.3125mm, 15.135mm)
  point Clamp_cbore_4-40_sketch44 = (35mm, -27.15625mm, 15.135mm)
  point Clamp_cbore_4-40_sketch45 = (-35mm, -27.15625mm, 15.135mm)
  point Clamp_cbore_4-40_sketch46 = (35mm, -39mm, 15.135mm)
  point Clamp_cbore_4-40_sketch47 = (23.333333mm, -39mm, 15.135mm)
  point Clamp_cbore_4-40_sketch48 = (11.666667mm, -39mm, 15.135mm)
  point Clamp_cbore_4-40_sketch49 = (0mm, -39mm, 15.135mm)
  point Clamp_cbore_4-40_sketch50 = (-11.666667mm, -39mm, 15.135mm)
  point Clamp_cbore_4-40_sketch51 = (-23.333333mm, -39mm, 15.135mm)
  point Clamp_cbore_4-40_sketch52 = (-35mm, -39mm, 15.135mm)
  point Clamp_cbore_4-40_sketch53 = (35mm, 8.375mm, 15.135mm)
  point Clamp_cbore_4-40_sketch54 = (24mm, 8.375mm, 15.135mm)
  point Clamp_cbore_4-40_sketch55 = (12mm, 8.375mm, 15.135mm)
  point Clamp_cbore_4-40_sketch56 = (-12mm, 8.375mm, 15.135mm)
  point Clamp_cbore_4-40_sketch57 = (-24mm, 8.375mm, 15.135mm)
  point Clamp_cbore_4-40_sketch58 = (-35mm, 8.375mm, 15.135mm)
  point Clamp_cbore_4-40_sketch59 = (0mm, 0mm, 15.135mm)
  point Clamp_cbore_4-40_sketch60 = (35mm, -3.46875mm, 15.135mm)
  point Clamp_cbore_4-40_sketch61 = (-35mm, -3.46875mm, 15.135mm)
  point Clamp_cbore_4-40_sketch62 = (35mm, -15.3125mm, 15.135mm)
  point Clamp_cbore_4-40_sketch63 = (-35mm, -15.3125mm, 15.135mm)
  point Clamp_cbore_4-40_sketch64 = (35mm, -27.15625mm, 15.135mm)
  point Clamp_cbore_4-40_sketch65 = (-35mm, -27.15625mm, 15.135mm)
  point Clamp_cbore_4-40_sketch66 = (35mm, -39mm, 15.135mm)
  point Clamp_cbore_4-40_sketch67 = (23.333333mm, -39mm, 15.135mm)
  point Clamp_cbore_4-40_sketch68 = (11.666667mm, -39mm, 15.135mm)
  point Clamp_cbore_4-40_sketch69 = (0mm, -39mm, 15.135mm)
  point Clamp_cbore_4-40_sketch70 = (-11.666667mm, -39mm, 15.135mm)
  point Clamp_cbore_4-40_sketch71 = (-23.333333mm, -39mm, 15.135mm)
  point Clamp_cbore_4-40_sketch72 = (-35mm, -39mm, 15.135mm)
  point Clamp_cbore_4-40_sketch73 = (35mm, 8.375mm, 15.135mm)
  point Clamp_cbore_4-40_sketch74 = (24mm, 8.375mm, 15.135mm)
  point Clamp_cbore_4-40_sketch75 = (12mm, 8.375mm, 15.135mm)
  point Clamp_cbore_4-40_sketch76 = (-12mm, 8.375mm, 15.135mm)
  point Clamp_cbore_4-40_sketch77 = (-24mm, 8.375mm, 15.135mm)
  point Clamp_cbore_4-40_sketch78 = (-35mm, 8.375mm, 15.135mm)
  point Clamp_cbore_4-40_sketch79 = (0mm, 0mm, 15.135mm)
  point Clamp_cbore_4-40_sketch80 = (35mm, -3.46875mm, 15.135mm)
  point Clamp_cbore_4-40_sketch81 = (-35mm, -3.46875mm, 15.135mm)
  point Clamp_cbore_4-40_sketch82 = (35mm, -15.3125mm, 15.135mm)
  point Clamp_cbore_4-40_sketch83 = (-35mm, -15.3125mm, 15.135mm)
  point Clamp_cbore_4-40_sketch84 = (35mm, -27.15625mm, 15.135mm)
  point Clamp_cbore_4-40_sketch85 = (-35mm, -27.15625mm, 15.135mm)
  point Clamp_cbore_4-40_sketch86 = (35mm, -39mm, 15.135mm)
  point Clamp_cbore_4-40_sketch87 = (23.333333mm, -39mm, 15.135mm)
  point Clamp_cbore_4-40_sketch88 = (11.666667mm, -39mm, 15.135mm)
  point Clamp_cbore_4-40_sketch89 = (0mm, -39mm, 15.135mm)
  point Clamp_cbore_4-40_sketch90 = (-11.666667mm, -39mm, 15.135mm)
  point Clamp_cbore_4-40_sketch91 = (-23.333333mm, -39mm, 15.135mm)
  point Clamp_cbore_4-40_sketch92 = (-35mm, -39mm, 15.135mm)
  point Clamp_cbore_4-40_sketch93 = (35mm, 8.375mm, 15.135mm)
  point Clamp_cbore_4-40_sketch94 = (24mm, 8.375mm, 15.135mm)
  point Clamp_cbore_4-40_sketch95 = (12mm, 8.375mm, 15.135mm)
  point Clamp_cbore_4-40_sketch96 = (-12mm, 8.375mm, 15.135mm)
  point Clamp_cbore_4-40_sketch97 = (-24mm, 8.375mm, 15.135mm)
  point Clamp_cbore_4-40_sketch98 = (-35mm, 8.375mm, 15.135mm)
  point Clamp_cbore_4-40_sketch99 = (0mm, 0mm, 15.135mm)
  point Clamp_cbore_4-40_sketch100 = (35mm, -3.46875mm, 15.135mm)
  point Clamp_cbore_4-40_sketch101 = (-35mm, -3.46875mm, 15.135mm)
  point Clamp_cbore_4-40_sketch102 = (35mm, -15.3125mm, 15.135mm)
  point Clamp_cbore_4-40_sketch103 = (-35mm, -15.3125mm, 15.135mm)
  point Clamp_cbore_4-40_sketch104 = (35mm, -27.15625mm, 15.135mm)
  point Clamp_cbore_4-40_sketch105 = (-35mm, -27.15625mm, 15.135mm)
  point Clamp_cbore_4-40_sketch106 = (35mm, -39mm, 15.135mm)
  point Clamp_cbore_4-40_sketch107 = (23.333333mm, -39mm, 15.135mm)
  point Clamp_cbore_4-40_sketch108 = (11.666667mm, -39mm, 15.135mm)
  point Clamp_cbore_4-40_sketch109 = (0mm, -39mm, 15.135mm)
  point Clamp_cbore_4-40_sketch110 = (-11.666667mm, -39mm, 15.135mm)
  point Clamp_cbore_4-40_sketch111 = (-23.333333mm, -39mm, 15.135mm)
  point Clamp_cbore_4-40_sketch112 = (-35mm, -39mm, 15.135mm)
  point Clamp_cbore_4-40_sketch113 = (35mm, 8.375mm, 15.135mm)
  point Clamp_cbore_4-40_sketch114 = (24mm, 8.375mm, 15.135mm)
  point Clamp_cbore_4-40_sketch115 = (12mm, 8.375mm, 15.135mm)
  point Clamp_cbore_4-40_sketch116 = (-12mm, 8.375mm, 15.135mm)
  point Clamp_cbore_4-40_sketch117 = (-24mm, 8.375mm, 15.135mm)
  point Clamp_cbore_4-40_sketch118 = (-35mm, 8.375mm, 15.135mm)
  point Clamp_cbore_4-40_sketch119 = (0mm, 0mm, 15.135mm)
  point Clamp_cbore_4-40_sketch120 = (35mm, -3.46875mm, 15.135mm)
  point Clamp_cbore_4-40_sketch121 = (-35mm, -3.46875mm, 15.135mm)
  point Clamp_cbore_4-40_sketch122 = (35mm, -15.3125mm, 15.135mm)
  point Clamp_cbore_4-40_sketch123 = (-35mm, -15.3125mm, 15.135mm)
  point Clamp_cbore_4-40_sketch124 = (35mm, -27.15625mm, 15.135mm)
  point Clamp_cbore_4-40_sketch125 = (-35mm, -27.15625mm, 15.135mm)
  point Clamp_cbore_4-40_sketch126 = (35mm, -39mm, 15.135mm)
  point Clamp_cbore_4-40_sketch127 = (23.333333mm, -39mm, 15.135mm)
  point Clamp_cbore_4-40_sketch128 = (11.666667mm, -39mm, 15.135mm)
  point Clamp_cbore_4-40_sketch129 = (0mm, -39mm, 15.135mm)
  point Clamp_cbore_4-40_sketch130 = (-11.666667mm, -39mm, 15.135mm)
  point Clamp_cbore_4-40_sketch131 = (-23.333333mm, -39mm, 15.135mm)
  point Clamp_cbore_4-40_sketch132 = (-35mm, -39mm, 15.135mm)
  point Clamp_cbore_4-40_sketch133 = (35mm, 8.375mm, 15.135mm)
  point Clamp_cbore_4-40_sketch134 = (24mm, 8.375mm, 15.135mm)
  point Clamp_cbore_4-40_sketch135 = (12mm, 8.375mm, 15.135mm)
  point Clamp_cbore_4-40_sketch136 = (-12mm, 8.375mm, 15.135mm)
  point Clamp_cbore_4-40_sketch137 = (-24mm, 8.375mm, 15.135mm)
  point Clamp_cbore_4-40_sketch138 = (-35mm, 8.375mm, 15.135mm)
  point Clamp_cbore_4-40_sketch139 = (0mm, 0mm, 15.135mm)
  point Clamp_cbore_4-40_sketch140 = (35mm, -15.3125mm, 15.135mm)
  point Clamp_cbore_4-40_sketch141 = (-35mm, -15.3125mm, 15.135mm)
  point Clamp_cbore_4-40_sketch142 = (35mm, -39mm, 15.135mm)
  point Clamp_cbore_4-40_sketch143 = (0mm, -39mm, 15.135mm)
  point Clamp_cbore_4-40_sketch144 = (-35mm, -39mm, 15.135mm)
  point Clamp_cbore_4-40_sketch145 = (35mm, 8.375mm, 15.135mm)
  point Clamp_cbore_4-40_sketch146 = (12mm, 8.375mm, 15.135mm)
  point Clamp_cbore_4-40_sketch147 = (-12mm, 8.375mm, 15.135mm)
  point Clamp_cbore_4-40_sketch148 = (-35mm, 8.375mm, 15.135mm)
  point Clamp_cbore_4-40_sketch149 = (0mm, 0mm, 15.135mm)
  point Clamp_cbore_4-40_sketch150 = (35mm, -9.6275mm, 15.135mm)
  point Clamp_cbore_4-40_sketch151 = (-35mm, -9.6275mm, 15.135mm)
  point Clamp_cbore_4-40_sketch152 = (35mm, -27.63mm, 15.135mm)
  point Clamp_cbore_4-40_sketch153 = (0mm, -27.63mm, 15.135mm)
  point Clamp_cbore_4-40_sketch154 = (-35mm, -27.63mm, 15.135mm)
  point Clamp_cbore_4-40_sketch155 = (35mm, 8.375mm, 15.135mm)
  point Clamp_cbore_4-40_sketch156 = (12mm, 8.375mm, 15.135mm)
  point Clamp_cbore_4-40_sketch157 = (-12mm, 8.375mm, 15.135mm)
  point Clamp_cbore_4-40_sketch158 = (-35mm, 8.375mm, 15.135mm)
  point Clamp_cbore_4-40_sketch159 = (0mm, 0mm, 15.135mm)
  Solid1, Solid1_1 = imported_body(C:\Users\epm114\Documents\GitHub\Cavity work\coffin_4Q\inventor_files\coffin_4Q_hfss.stp)
  cavity [vacuum] = box(corner=(-40mm, -32.63mm, -15.135mm), size=(80mm, 45.38mm, 30.27mm))
  cavity.subtract(Solid1, Solid1_1)
  ro_pin_1 = cylinder(axis=Y, base_centre=($ro1_x, $y_front - $ro_pin_len, $ro1_z), radius=$pin_r, height=$ro_pin_len)
  ro_pin_2 = cylinder(axis=Y, base_centre=($ro2_x, $y_front - $ro_pin_len, $ro2_z), radius=$pin_r, height=$ro_pin_len)
  drive_pin_1 = cylinder(axis=Z, base_centre=($q1_x, -($cav_W/2 + $drive_dy_outer), $block_H/2 - $drive_pin_len), radius=$pin_r, height=$drive_pin_len)
  drive_pin_2 = cylinder(axis=Z, base_centre=($q2_x, -($cav_W/2 + $drive_dy_inner), $block_H/2 - $drive_pin_len), radius=$pin_r, height=$drive_pin_len)
  drive_pin_3 = cylinder(axis=Z, base_centre=($q3_x, -($cav_W/2 + $drive_dy_inner), $block_H/2 - $drive_pin_len), radius=$pin_r, height=$drive_pin_len)
  drive_pin_4 = cylinder(axis=Z, base_centre=($q4_x, -($cav_W/2 + $drive_dy_outer), $block_H/2 - $drive_pin_len), radius=$pin_r, height=$drive_pin_len)
  cavity.subtract(ro_pin_1, ro_pin_2, drive_pin_1..drive_pin_4)
  substrate_1 [sapphire] = box(corner=(-16.975mm, -18.13mm, -0.5mm), size=(2.45mm, 16.63mm, 0.43mm))
  pad_1a = rectangle(corner=(-15.85mm, -5.565mm, -0.07mm), x_size=0.2mm, y_size=4mm)
  lead_1a = rectangle(corner=(-15.765mm, -5.65mm, -0.07mm), x_size=0.03mm, y_size=0.085mm)
  pad_1b = rectangle(corner=(-15.85mm, -7.765mm, -0.07mm), x_size=0.2mm, y_size=2mm)
  lead_1b = rectangle(corner=(-15.765mm, -5.765mm, -0.07mm), x_size=0.03mm, y_size=0.085mm)
  pad_1a.unite(lead_1a)
  pad_1b.unite(lead_1b)
  jj_1 = rectangle(corner=(-15.765mm, -5.68mm, -0.07mm), x_size=0.03mm, y_size=0.03mm)
  jj_line_1 [non-model] = polyline((-15.75mm, -5.68mm, -0.07mm) (-15.75mm, -5.65mm, -0.07mm))
  substrate_2 [sapphire] = box(corner=(-6.475mm, -18.53mm, -0.5mm), size=(2.45mm, 16.63mm, 0.43mm))
  pad_2a = rectangle(corner=(-5.35mm, -5.965mm, -0.07mm), x_size=0.2mm, y_size=4mm)
  lead_2a = rectangle(corner=(-5.265mm, -6.05mm, -0.07mm), x_size=0.03mm, y_size=0.085mm)
  pad_2b = rectangle(corner=(-5.35mm, -8.165mm, -0.07mm), x_size=0.2mm, y_size=2mm)
  lead_2b = rectangle(corner=(-5.265mm, -6.165mm, -0.07mm), x_size=0.03mm, y_size=0.085mm)
  pad_2a.unite(lead_2a)
  pad_2b.unite(lead_2b)
  jj_2 = rectangle(corner=(-5.265mm, -6.08mm, -0.07mm), x_size=0.03mm, y_size=0.03mm)
  jj_line_2 [non-model] = polyline((-5.25mm, -6.08mm, -0.07mm) (-5.25mm, -6.05mm, -0.07mm))
  substrate_3 [sapphire] = box(corner=(4.025mm, -18.53mm, -0.5mm), size=(2.45mm, 16.63mm, 0.43mm))
  pad_3a = rectangle(corner=(5.15mm, -5.965mm, -0.07mm), x_size=0.2mm, y_size=4mm)
  lead_3a = rectangle(corner=(5.235mm, -6.05mm, -0.07mm), x_size=0.03mm, y_size=0.085mm)
  pad_3b = rectangle(corner=(5.15mm, -8.165mm, -0.07mm), x_size=0.2mm, y_size=2mm)
  lead_3b = rectangle(corner=(5.235mm, -6.165mm, -0.07mm), x_size=0.03mm, y_size=0.085mm)
  pad_3a.unite(lead_3a)
  pad_3b.unite(lead_3b)
  jj_3 = rectangle(corner=(5.235mm, -6.08mm, -0.07mm), x_size=0.03mm, y_size=0.03mm)
  jj_line_3 [non-model] = polyline((5.25mm, -6.08mm, -0.07mm) (5.25mm, -6.05mm, -0.07mm))
  substrate_4 [sapphire] = box(corner=(14.525mm, -18.13mm, -0.5mm), size=(2.45mm, 16.63mm, 0.43mm))
  pad_4a = rectangle(corner=(15.65mm, -5.565mm, -0.07mm), x_size=0.2mm, y_size=4mm)
  lead_4a = rectangle(corner=(15.735mm, -5.65mm, -0.07mm), x_size=0.03mm, y_size=0.085mm)
  pad_4b = rectangle(corner=(15.65mm, -7.765mm, -0.07mm), x_size=0.2mm, y_size=2mm)
  lead_4b = rectangle(corner=(15.735mm, -5.765mm, -0.07mm), x_size=0.03mm, y_size=0.085mm)
  pad_4a.unite(lead_4a)
  pad_4b.unite(lead_4b)
  jj_4 = rectangle(corner=(15.735mm, -5.68mm, -0.07mm), x_size=0.03mm, y_size=0.03mm)
  jj_line_4 [non-model] = polyline((15.75mm, -5.68mm, -0.07mm) (15.75mm, -5.65mm, -0.07mm))
boundaries and excitations:
  ro1: Impedance Faces=cavity.face(at (0, 12.75, -5)) Resistance=373.3629 Reactance=0
  ro2: Impedance Faces=cavity.face(at (0, 12.75, 5)) Resistance=373.3629 Reactance=0
  drive1: Impedance Faces=cavity.face(at (-15.75, -10, 15.135)) Resistance=373.3629 Reactance=0
  drive2: Impedance Faces=cavity.face(at (-5.25, -10.4, 15.135)) Resistance=373.3629 Reactance=0
  drive3: Impedance Faces=cavity.face(at (5.25, -10.4, 15.135)) Resistance=373.3629 Reactance=0
  drive4: Impedance Faces=cavity.face(at (15.75, -10, 15.135)) Resistance=373.3629 Reactance=0
  cryo_copper: Finite Conductivity Faces=cavity.face(at (5.25, -18.315, 0), at (-5.25, -18.315, 0), at (-15.75, -18.315, 0), at (0, 0, 10.135), at (-29.4142, -3.41421, 0), at (0, -4, 0), at (29.4142, -3.41421, 0), at (30, 0, 0), at (29.4142, 3.41421, 0), at (0, 4, 0), at (-29.4142, 3.41421, 0), at (-30, 0, 0)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) UseMaterial Material=cryo_copper IsInternal
  pads_1: Perfect E Objects=[pad_1a, pad_1b]
  pads_2: Perfect E Objects=[pad_2a, pad_2b]
  jj2: Lumped RLC Objects=jj_2 CurrentLine{(-5.25, -6.08, -0.07) -> (-5.25, -6.05, -0.07)} RLC_Type=Parallel Inductance=Lj2
  pads_3: Perfect E Objects=[pad_3a, pad_3b]
  jj3: Lumped RLC Objects=jj_3 CurrentLine{(5.25, -6.08, -0.07) -> (5.25, -6.05, -0.07)} RLC_Type=Parallel Inductance=Lj3
  pads_4: Perfect E Objects=[pad_4a, pad_4b]
  jj4: Lumped RLC Objects=jj_4 CurrentLine{(15.75, -5.68, -0.07) -> (15.75, -5.65, -0.07)} RLC_Type=Parallel Inductance=Lj4
  jj1: Lumped Port Objects=jj_1 LumpedPortType=Modal Modes{Mode1{IntLine{(-15.75, -5.68, -0.07) -> (-15.75, -5.65, -0.07)} CharImp=Zpi}} Impedance=1000000ohm
mesh:
  tmon_substrate: LengthBased Objects=[substrate_1..substrate_4] MaxLength=0.5mm
  tmon_pads: LengthBased Objects=[pad_1a, pad_1b, pad_2a, pad_2b, pad_3a, pad_3b, pad_4a, pad_4b] MaxLength=50um
  tmon_jj: LengthBased Objects=[jj_1..jj_4] MaxLength=10um
setups:
  DM_1port: HfssDriven Frequency=4.5GHz MaxDeltaS=0.01 MaximumPasses=10 MinimumPasses=3 MinimumConvergedPasses=3 PercentRefinement=30 BasisOrder=-1 PortAccuracy=2 DrivenSolverType="Direct Solver"
    sweep Sweep_000_ZDUPC6: 3GHz to 3.1GHz, 10000 points; Type=Fast
    sweep Sweep_001_PGV3KU: 3.1GHz to 3.2GHz, 10000 points; Type=Fast
    sweep Sweep_002_63JDWU: 3.2GHz to 3.3GHz, 10000 points; Type=Fast
    sweep Sweep_003_4GE22E: 3.3GHz to 3.4GHz, 10000 points; Type=Fast
    sweep Sweep_004_TLVJXF: 3.4GHz to 3.5GHz, 10000 points; Type=Fast
    sweep Sweep_005_P1V25N: 3.5GHz to 3.6GHz, 10000 points; Type=Fast
    sweep Sweep_006_BOUR24: 3.6GHz to 3.7GHz, 10000 points; Type=Fast
    sweep Sweep_007_GXKYQJ: 3.7GHz to 3.8GHz, 10000 points; Type=Fast
    sweep Sweep_008_F0A7YO: 3.8GHz to 3.9GHz, 10000 points; Type=Fast
    sweep Sweep_009_0H52AF: 3.9GHz to 4GHz, 10000 points; Type=Fast
    sweep Sweep_010_G4BO4V: 4GHz to 4.1GHz, 10000 points; Type=Fast
    sweep Sweep_011_1MTEQE: 4.1GHz to 4.2GHz, 10000 points; Type=Fast
    sweep Sweep_012_YV25II: 4.2GHz to 4.3GHz, 10000 points; Type=Fast
    sweep Sweep_013_ZXERZ3: 4.3GHz to 4.4GHz, 10000 points; Type=Fast
    sweep Sweep_014_QUPBSJ: 4.4GHz to 4.5GHz, 10000 points; Type=Fast
    sweep Sweep_015_X4XTW3: 4.5GHz to 4.6GHz, 10000 points; Type=Fast
    sweep Sweep_016_N678DK: 4.6GHz to 4.7GHz, 10000 points; Type=Fast
    sweep Sweep_017_K6Z87M: 4.7GHz to 4.8GHz, 10000 points; Type=Fast
    sweep Sweep_018_7PZPC2: 4.8GHz to 4.9GHz, 10000 points; Type=Fast
    sweep Sweep_019_Q0XU1N: 4.9GHz to 5GHz, 10000 points; Type=Fast
    sweep Sweep_020_WYPBA3: 5GHz to 5.1GHz, 10000 points; Type=Fast
    sweep Sweep_021_RMDHZD: 5.1GHz to 5.2GHz, 10000 points; Type=Fast
    sweep Sweep_022_N3ALUK: 5.2GHz to 5.3GHz, 10000 points; Type=Fast
    sweep Sweep_023_LYUEVU: 5.3GHz to 5.4GHz, 10000 points; Type=Fast
    sweep Sweep_024_T9BKYX: 5.4GHz to 5.5GHz, 10000 points; Type=Fast
    sweep Sweep_025_ZQZR1P: 5.5GHz to 5.6GHz, 10000 points; Type=Fast
    sweep Sweep_026_5D22U1: 5.6GHz to 5.7GHz, 10000 points; Type=Fast
    sweep Sweep_027_D27N5K: 5.7GHz to 5.8GHz, 10000 points; Type=Fast
    sweep Sweep_028_Y5HGYS: 5.8GHz to 5.9GHz, 10000 points; Type=Fast
    sweep Sweep_029_FKAK3O: 5.9GHz to 6GHz, 10000 points; Type=Fast
    sweep Sweep_030_MROO9A: 6GHz to 6.1GHz, 10000 points; Type=Fast
    sweep Sweep_031_MLEEZF: 6.1GHz to 6.2GHz, 10000 points; Type=Fast
    sweep Sweep_032_KUXOJ4: 6.2GHz to 6.3GHz, 10000 points; Type=Fast
    sweep Sweep_033_SGOOV8: 6.3GHz to 6.4GHz, 10000 points; Type=Fast
    sweep Sweep_034_Y4V3A7: 6.4GHz to 6.5GHz, 10000 points; Type=Fast
    sweep Sweep_035_PHSPUS: 6.5GHz to 6.6GHz, 10000 points; Type=Fast
    sweep Sweep_036_ATR5RV: 6.6GHz to 6.7GHz, 10000 points; Type=Fast
    sweep Sweep_037_QC2IBA: 6.7GHz to 6.8GHz, 10000 points; Type=Fast
    sweep Sweep_038_8EKLU1: 6.8GHz to 6.9GHz, 10000 points; Type=Fast
    sweep Sweep_039_BAWUWO: 6.9GHz to 7GHz, 10000 points; Type=Fast
    sweep Sweep_040_MX195U: 7GHz to 7.1GHz, 10000 points; Type=Fast
    sweep Sweep_041_EB1SSD: 7.1GHz to 7.2GHz, 10000 points; Type=Fast
    sweep Sweep_042_TG4TAH: 7.2GHz to 7.3GHz, 10000 points; Type=Fast
    sweep Sweep_043_A7MVYB: 7.3GHz to 7.4GHz, 10000 points; Type=Fast
    sweep Sweep_044_AB99PP: 7.4GHz to 7.5GHz, 10000 points; Type=Fast
    sweep Sweep_045_ZL4IPA: 7.5GHz to 7.6GHz, 10000 points; Type=Fast
    sweep Sweep_046_DVWAQ7: 7.6GHz to 7.7GHz, 10000 points; Type=Fast
    sweep Sweep_047_2DUD3M: 7.7GHz to 7.8GHz, 10000 points; Type=Fast
    sweep Sweep_048_ITIU02: 7.8GHz to 7.9GHz, 10000 points; Type=Fast
    sweep Sweep_049_GXE738: 7.9GHz to 8GHz, 10000 points; Type=Fast
    sweep Sweep_050_KNH8L4: 8GHz to 8.1GHz, 10000 points; Type=Fast
    sweep Sweep_051_EE8Z8L: 8.1GHz to 8.2GHz, 10000 points; Type=Fast
    sweep Sweep_052_EC9KUM: 8.2GHz to 8.3GHz, 10000 points; Type=Fast
    sweep Sweep_053_HP3H6U: 8.3GHz to 8.4GHz, 10000 points; Type=Fast
    sweep Sweep_054_DOY41L: 8.4GHz to 8.5GHz, 10000 points; Type=Fast
    sweep Sweep_055_TIDVYG: 8.5GHz to 8.6GHz, 10000 points; Type=Fast
    sweep Sweep_056_ISXN5K: 8.6GHz to 8.7GHz, 10000 points; Type=Fast
    sweep Sweep_057_721BML: 8.7GHz to 8.8GHz, 10000 points; Type=Fast
    sweep Sweep_058_JGKP9J: 8.8GHz to 8.9GHz, 10000 points; Type=Fast
    sweep Sweep_059_98I30A: 8.9GHz to 9GHz, 10000 points; Type=Fast
    sweep Sweep_060_UG14Z5: 9GHz to 9.1GHz, 10000 points; Type=Fast
    sweep Sweep_061_8O1105: 9.1GHz to 9.2GHz, 10000 points; Type=Fast
    sweep Sweep_062_2RIXBG: 9.2GHz to 9.3GHz, 10000 points; Type=Fast
    sweep Sweep_063_KB6LO7: 9.3GHz to 9.4GHz, 10000 points; Type=Fast
    sweep Sweep_064_R01HGB: 9.4GHz to 9.5GHz, 10000 points; Type=Fast
    sweep Sweep_065_PV6HXM: 9.5GHz to 9.6GHz, 10000 points; Type=Fast
    sweep Sweep_066_Z7L587: 9.6GHz to 9.7GHz, 10000 points; Type=Fast
    sweep Sweep_067_Y92Y56: 9.7GHz to 9.8GHz, 10000 points; Type=Fast
    sweep Sweep_068_XF5WXA: 9.8GHz to 9.9GHz, 10000 points; Type=Fast
    sweep Sweep_069_0HSL36: 9.9GHz to 10GHz, 10000 points; Type=Fast
source amplitudes:
  jj1:1: 1W 0deg

design EM_drive_check (HFSS, Eigenmode, model units mm)
variables:
  Lj1 = 9.5nH
  Lj2 = 10.5nH
  Lj3 = 11.5nH
  Lj4 = 12.5nH
geometry:
  point Clamp_cbore_4-40_sketch = (35mm, -9.6275mm, 15.135mm)
  point Clamp_cbore_4-40_sketch1 = (-35mm, -9.6275mm, 15.135mm)
  point Clamp_cbore_4-40_sketch2 = (35mm, -27.63mm, 15.135mm)
  point Clamp_cbore_4-40_sketch3 = (0mm, -27.63mm, 15.135mm)
  point Clamp_cbore_4-40_sketch4 = (-35mm, -27.63mm, 15.135mm)
  point Clamp_cbore_4-40_sketch5 = (35mm, 8.375mm, 15.135mm)
  point Clamp_cbore_4-40_sketch6 = (12mm, 8.375mm, 15.135mm)
  point Clamp_cbore_4-40_sketch7 = (-12mm, 8.375mm, 15.135mm)
  point Clamp_cbore_4-40_sketch8 = (-35mm, 8.375mm, 15.135mm)
  point Clamp_cbore_4-40_sketch9 = (0mm, 0mm, 15.135mm)
  point Clamp_cbore_4-40_sketch10 = (35mm, -9.6275mm, 15.135mm)
  point Clamp_cbore_4-40_sketch11 = (-35mm, -9.6275mm, 15.135mm)
  point Clamp_cbore_4-40_sketch12 = (35mm, -27.63mm, 15.135mm)
  point Clamp_cbore_4-40_sketch13 = (0mm, -27.63mm, 15.135mm)
  point Clamp_cbore_4-40_sketch14 = (-35mm, -27.63mm, 15.135mm)
  point Clamp_cbore_4-40_sketch15 = (35mm, 8.375mm, 15.135mm)
  point Clamp_cbore_4-40_sketch16 = (12mm, 8.375mm, 15.135mm)
  point Clamp_cbore_4-40_sketch17 = (-12mm, 8.375mm, 15.135mm)
  point Clamp_cbore_4-40_sketch18 = (-35mm, 8.375mm, 15.135mm)
  point Clamp_cbore_4-40_sketch19 = (0mm, 0mm, 15.135mm)
  point Clamp_cbore_4-40_sketch20 = (35mm, -9.6275mm, 15.135mm)
  point Clamp_cbore_4-40_sketch21 = (-35mm, -9.6275mm, 15.135mm)
  point Clamp_cbore_4-40_sketch22 = (35mm, -27.63mm, 15.135mm)
  point Clamp_cbore_4-40_sketch23 = (0mm, -27.63mm, 15.135mm)
  point Clamp_cbore_4-40_sketch24 = (-35mm, -27.63mm, 15.135mm)
  point Clamp_cbore_4-40_sketch25 = (35mm, 8.375mm, 15.135mm)
  point Clamp_cbore_4-40_sketch26 = (12mm, 8.375mm, 15.135mm)
  point Clamp_cbore_4-40_sketch27 = (-12mm, 8.375mm, 15.135mm)
  point Clamp_cbore_4-40_sketch28 = (-35mm, 8.375mm, 15.135mm)
  point Clamp_cbore_4-40_sketch29 = (0mm, 0mm, 15.135mm)
  point Clamp_cbore_4-40_sketch30 = (35mm, -9.6275mm, 15.135mm)
  point Clamp_cbore_4-40_sketch31 = (-35mm, -9.6275mm, 15.135mm)
  point Clamp_cbore_4-40_sketch32 = (35mm, -27.63mm, 15.135mm)
  point Clamp_cbore_4-40_sketch33 = (0mm, -27.63mm, 15.135mm)
  point Clamp_cbore_4-40_sketch34 = (-35mm, -27.63mm, 15.135mm)
  point Clamp_cbore_4-40_sketch35 = (35mm, 8.375mm, 15.135mm)
  point Clamp_cbore_4-40_sketch36 = (12mm, 8.375mm, 15.135mm)
  point Clamp_cbore_4-40_sketch37 = (-12mm, 8.375mm, 15.135mm)
  point Clamp_cbore_4-40_sketch38 = (-35mm, 8.375mm, 15.135mm)
  point Clamp_cbore_4-40_sketch39 = (0mm, 0mm, 15.135mm)
  point Clamp_cbore_4-40_sketch40 = (35mm, -9.6275mm, 15.135mm)
  point Clamp_cbore_4-40_sketch41 = (-35mm, -9.6275mm, 15.135mm)
  point Clamp_cbore_4-40_sketch42 = (35mm, -27.63mm, 15.135mm)
  point Clamp_cbore_4-40_sketch43 = (0mm, -27.63mm, 15.135mm)
  point Clamp_cbore_4-40_sketch44 = (-35mm, -27.63mm, 15.135mm)
  point Clamp_cbore_4-40_sketch45 = (35mm, 8.375mm, 15.135mm)
  point Clamp_cbore_4-40_sketch46 = (12mm, 8.375mm, 15.135mm)
  point Clamp_cbore_4-40_sketch47 = (-12mm, 8.375mm, 15.135mm)
  point Clamp_cbore_4-40_sketch48 = (-35mm, 8.375mm, 15.135mm)
  point Clamp_cbore_4-40_sketch49 = (0mm, 0mm, 15.135mm)
  point Clamp_cbore_4-40_sketch50 = (35mm, -9.6275mm, 15.135mm)
  point Clamp_cbore_4-40_sketch51 = (-35mm, -9.6275mm, 15.135mm)
  point Clamp_cbore_4-40_sketch52 = (35mm, -27.63mm, 15.135mm)
  point Clamp_cbore_4-40_sketch53 = (0mm, -27.63mm, 15.135mm)
  point Clamp_cbore_4-40_sketch54 = (-35mm, -27.63mm, 15.135mm)
  point Clamp_cbore_4-40_sketch55 = (35mm, 8.375mm, 15.135mm)
  point Clamp_cbore_4-40_sketch56 = (12mm, 8.375mm, 15.135mm)
  point Clamp_cbore_4-40_sketch57 = (-12mm, 8.375mm, 15.135mm)
  point Clamp_cbore_4-40_sketch58 = (-35mm, 8.375mm, 15.135mm)
  point Clamp_cbore_4-40_sketch59 = (0mm, 0mm, 15.135mm)
  point Clamp_cbore_4-40_sketch60 = (35mm, -9.6275mm, 15.135mm)
  point Clamp_cbore_4-40_sketch61 = (-35mm, -9.6275mm, 15.135mm)
  point Clamp_cbore_4-40_sketch62 = (35mm, -27.63mm, 15.135mm)
  point Clamp_cbore_4-40_sketch63 = (0mm, -27.63mm, 15.135mm)
  point Clamp_cbore_4-40_sketch64 = (-35mm, -27.63mm, 15.135mm)
  point Clamp_cbore_4-40_sketch65 = (35mm, 8.375mm, 15.135mm)
  point Clamp_cbore_4-40_sketch66 = (12mm, 8.375mm, 15.135mm)
  point Clamp_cbore_4-40_sketch67 = (-12mm, 8.375mm, 15.135mm)
  point Clamp_cbore_4-40_sketch68 = (-35mm, 8.375mm, 15.135mm)
  point Clamp_cbore_4-40_sketch69 = (0mm, 0mm, 15.135mm)
  point Clamp_cbore_4-40_sketch70 = (35mm, -9.6275mm, 15.135mm)
  point Clamp_cbore_4-40_sketch71 = (-35mm, -9.6275mm, 15.135mm)
  point Clamp_cbore_4-40_sketch72 = (35mm, -27.63mm, 15.135mm)
  point Clamp_cbore_4-40_sketch73 = (0mm, -27.63mm, 15.135mm)
  point Clamp_cbore_4-40_sketch74 = (-35mm, -27.63mm, 15.135mm)
  point Clamp_cbore_4-40_sketch75 = (35mm, 8.375mm, 15.135mm)
  point Clamp_cbore_4-40_sketch76 = (12mm, 8.375mm, 15.135mm)
  point Clamp_cbore_4-40_sketch77 = (-12mm, 8.375mm, 15.135mm)
  point Clamp_cbore_4-40_sketch78 = (-35mm, 8.375mm, 15.135mm)
  point Clamp_cbore_4-40_sketch79 = (0mm, 0mm, 15.135mm)
  Solid1, Solid1_1 = imported_body(C:\Users\epm114\Documents\GitHub\Cavity work\coffin_4Q\inventor_files\coffin_4Q_hfss.stp)
  cavity [vacuum] = box(corner=(-40mm, -32.63mm, -15.135mm), size=(80mm, 45.38mm, 30.27mm))
  cavity.subtract(Solid1, Solid1_1)
  ro_pin_1 = cylinder(axis=Y, base_centre=($ro1_x, $y_front - $ro_pin_len, $ro1_z), radius=$pin_r, height=$ro_pin_len)
  ro_pin_2 = cylinder(axis=Y, base_centre=($ro2_x, $y_front - $ro_pin_len, $ro2_z), radius=$pin_r, height=$ro_pin_len)
  drive_pin_1 = cylinder(axis=Z, base_centre=($q1_x, -($cav_W/2 + $drive_dy_outer), 6mm), radius=$pin_r, height=9.135mm)
  drive_pin_2 = cylinder(axis=Z, base_centre=($q2_x, -($cav_W/2 + $drive_dy_inner), 6mm), radius=$pin_r, height=9.135mm)
  drive_pin_3 = cylinder(axis=Z, base_centre=($q3_x, -($cav_W/2 + $drive_dy_inner), 6mm), radius=$pin_r, height=9.135mm)
  drive_pin_4 = cylinder(axis=Z, base_centre=($q4_x, -($cav_W/2 + $drive_dy_outer), 6mm), radius=$pin_r, height=9.135mm)
  cavity.subtract(ro_pin_1, ro_pin_2, drive_pin_1..drive_pin_4)
  substrate_1 [sapphire_lossless] = box(corner=(-16.975mm, -18.13mm, -0.5mm), size=(2.45mm, 16.63mm, 0.43mm))
  pad_1a = rectangle(corner=(-15.85mm, -5.565mm, -0.07mm), x_size=0.2mm, y_size=4mm)
  lead_1a = rectangle(corner=(-15.765mm, -5.65mm, -0.07mm), x_size=0.03mm, y_size=0.085mm)
  pad_1b = rectangle(corner=(-15.85mm, -7.765mm, -0.07mm), x_size=0.2mm, y_size=2mm)
  lead_1b = rectangle(corner=(-15.765mm, -5.765mm, -0.07mm), x_size=0.03mm, y_size=0.085mm)
  pad_1a.unite(lead_1a)
  pad_1b.unite(lead_1b)
  jj_1 = rectangle(corner=(-15.765mm, -5.68mm, -0.07mm), x_size=0.03mm, y_size=0.03mm)
  jj_line_1 [non-model] = polyline((-15.75mm, -5.68mm, -0.07mm) (-15.75mm, -5.65mm, -0.07mm))
  substrate_2 [sapphire_lossless] = box(corner=(-6.475mm, -18.53mm, -0.5mm), size=(2.45mm, 16.63mm, 0.43mm))
  pad_2a = rectangle(corner=(-5.35mm, -5.965mm, -0.07mm), x_size=0.2mm, y_size=4mm)
  lead_2a = rectangle(corner=(-5.265mm, -6.05mm, -0.07mm), x_size=0.03mm, y_size=0.085mm)
  pad_2b = rectangle(corner=(-5.35mm, -8.165mm, -0.07mm), x_size=0.2mm, y_size=2mm)
  lead_2b = rectangle(corner=(-5.265mm, -6.165mm, -0.07mm), x_size=0.03mm, y_size=0.085mm)
  pad_2a.unite(lead_2a)
  pad_2b.unite(lead_2b)
  jj_2 = rectangle(corner=(-5.265mm, -6.08mm, -0.07mm), x_size=0.03mm, y_size=0.03mm)
  jj_line_2 [non-model] = polyline((-5.25mm, -6.08mm, -0.07mm) (-5.25mm, -6.05mm, -0.07mm))
  substrate_3 [sapphire_lossless] = box(corner=(4.025mm, -18.53mm, -0.5mm), size=(2.45mm, 16.63mm, 0.43mm))
  pad_3a = rectangle(corner=(5.15mm, -5.965mm, -0.07mm), x_size=0.2mm, y_size=4mm)
  lead_3a = rectangle(corner=(5.235mm, -6.05mm, -0.07mm), x_size=0.03mm, y_size=0.085mm)
  pad_3b = rectangle(corner=(5.15mm, -8.165mm, -0.07mm), x_size=0.2mm, y_size=2mm)
  lead_3b = rectangle(corner=(5.235mm, -6.165mm, -0.07mm), x_size=0.03mm, y_size=0.085mm)
  pad_3a.unite(lead_3a)
  pad_3b.unite(lead_3b)
  jj_3 = rectangle(corner=(5.235mm, -6.08mm, -0.07mm), x_size=0.03mm, y_size=0.03mm)
  jj_line_3 [non-model] = polyline((5.25mm, -6.08mm, -0.07mm) (5.25mm, -6.05mm, -0.07mm))
  substrate_4 [sapphire_lossless] = box(corner=(14.525mm, -18.13mm, -0.5mm), size=(2.45mm, 16.63mm, 0.43mm))
  pad_4a = rectangle(corner=(15.65mm, -5.565mm, -0.07mm), x_size=0.2mm, y_size=4mm)
  lead_4a = rectangle(corner=(15.735mm, -5.65mm, -0.07mm), x_size=0.03mm, y_size=0.085mm)
  pad_4b = rectangle(corner=(15.65mm, -7.765mm, -0.07mm), x_size=0.2mm, y_size=2mm)
  lead_4b = rectangle(corner=(15.735mm, -5.765mm, -0.07mm), x_size=0.03mm, y_size=0.085mm)
  pad_4a.unite(lead_4a)
  pad_4b.unite(lead_4b)
  jj_4 = rectangle(corner=(15.735mm, -5.68mm, -0.07mm), x_size=0.03mm, y_size=0.03mm)
  jj_line_4 [non-model] = polyline((15.75mm, -5.68mm, -0.07mm) (15.75mm, -5.65mm, -0.07mm))
boundaries and excitations:
  drive1: Impedance Faces=cavity.face(at (-15.75, -10, 15.135)) Resistance=373.3629 Reactance=0
  drive2: Impedance Faces=cavity.face(at (-5.25, -10.4, 15.135)) Resistance=373.3629 Reactance=0
  drive3: Impedance Faces=cavity.face(at (5.25, -10.4, 15.135)) Resistance=373.3629 Reactance=0
  drive4: Impedance Faces=cavity.face(at (15.75, -10, 15.135)) Resistance=373.3629 Reactance=0
  pads_1: Perfect E Objects=[pad_1a, pad_1b]
  jj1: Lumped RLC Objects=jj_1 CurrentLine{(-15.75, -5.68, -0.07) -> (-15.75, -5.65, -0.07)} RLC_Type=Parallel Inductance=Lj1
  pads_2: Perfect E Objects=[pad_2a, pad_2b]
  jj2: Lumped RLC Objects=jj_2 CurrentLine{(-5.25, -6.08, -0.07) -> (-5.25, -6.05, -0.07)} RLC_Type=Parallel Inductance=Lj2
  pads_3: Perfect E Objects=[pad_3a, pad_3b]
  jj3: Lumped RLC Objects=jj_3 CurrentLine{(5.25, -6.08, -0.07) -> (5.25, -6.05, -0.07)} RLC_Type=Parallel Inductance=Lj3
  pads_4: Perfect E Objects=[pad_4a, pad_4b]
  jj4: Lumped RLC Objects=jj_4 CurrentLine{(15.75, -5.68, -0.07) -> (15.75, -5.65, -0.07)} RLC_Type=Parallel Inductance=Lj4
mesh:
  tmon_substrate: LengthBased Objects=[substrate_1..substrate_4] MaxLength=0.5mm
  tmon_pads: LengthBased Objects=[pad_1a, pad_1b, pad_2a, pad_2b, pad_3a, pad_3b, pad_4a, pad_4b] MaxLength=50um
  tmon_jj: LengthBased Objects=[jj_1..jj_4] MaxLength=10um
setups:
  EM_drive_check: HfssEigen MinimumFrequency=4GHz NumModes=8 MaxDeltaFreq=0.1 ConvergeOnRealFreq=true MaximumPasses=9 MinimumPasses=4 MinimumConvergedPasses=2 PercentRefinement=25 BasisOrder=-1
source amplitudes:
  #-10:1: 1 0deg
  #-10:2..#-10:8: 0 0deg
