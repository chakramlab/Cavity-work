# Ansys Electronics Desktop project, version 2023.2
project variables:
  $cav_L = 50mm
  $cav_W = 15mm
  $cav_H = 20.8mm
  $cav_r = 2mm
  $wall_x = 6mm
  $wall_z = 5mm
  $wall_back = 5mm
  $chip_T = 0.5mm
  $tunnel_W = 6.5mm
  $tunnel_L = 30mm
  $tunnel_r = 0mm
  $q1_x = -18.75mm
  $q2_x = -6.25mm
  $q3_x = 6.25mm
  $q4_x = 18.75mm
  $top_pocket_L = 10mm
  $top_pocket_D = 0.43mm
  $drive_dia = 2.946mm
  $drive_dy = 7.5mm
  $ro_dia = 2.946mm
  $ro_port_len = 8.75mm
  $ro1_x = 0mm
  $ro1_z = -5mm
  $ro2_x = 0mm
  $ro2_z = 5mm
  $ovl = 0.5mm
  $block_L = 62mm
  $block_H = 30.8mm
  $y_front = 16.25mm
  $y_back = 42.5mm
  $pin_r = 0.635mm
  $ro_pin_len = 5mm
  $drive_pin_gap = 2mm
  $drive_pin_len = $block_H/2 - $drive_pin_gap
materials:
  vacuum: permittivity=1
  cryo_copper: permittivity=1 permeability=1 conductivity=5800000000
  sapphire: permittivity=10
surface materials:
  Steel-oxidised-surface

design EM_Cavity (HFSS, Eigenmode, model units mm)
geometry:
  Solid1, Solid1_1 = imported_body(C:\Users\epm114\Documents\GitHub\Cavity work\coffin_4Q\inventor_files\coffin_4Q.stp)
  cavity [vacuum] = box(corner=(-31mm, -42.5mm, -15.4mm), size=(62mm, 58.75mm, 30.8mm))
  cavity.subtract(Solid1, Solid1_1)
  ro_pin_1 = cylinder(axis=Y, base_centre=($ro1_x, $y_front - $ro_pin_len, $ro1_z), radius=$pin_r, height=$ro_pin_len)
  ro_pin_2 = cylinder(axis=Y, base_centre=($ro2_x, $y_front - $ro_pin_len, $ro2_z), radius=$pin_r, height=$ro_pin_len)
  drive_pin_1 = cylinder(axis=Z, base_centre=($q1_x, -($cav_W/2 + $drive_dy), $block_H/2 - $drive_pin_len), radius=$pin_r, height=$drive_pin_len)
  drive_pin_2 = cylinder(axis=Z, base_centre=($q2_x, -($cav_W/2 + $drive_dy), $block_H/2 - $drive_pin_len), radius=$pin_r, height=$drive_pin_len)
  drive_pin_3 = cylinder(axis=Z, base_centre=($q3_x, -($cav_W/2 + $drive_dy), $block_H/2 - $drive_pin_len), radius=$pin_r, height=$drive_pin_len)
  drive_pin_4 = cylinder(axis=Z, base_centre=($q4_x, -($cav_W/2 + $drive_dy), $block_H/2 - $drive_pin_len), radius=$pin_r, height=$drive_pin_len)
  cavity.subtract(ro_pin_1, ro_pin_2, drive_pin_1..drive_pin_4)
boundaries and excitations:
  ro1: Impedance Faces=cavity.face(at (0, 16.25, -5)) Resistance=50 Reactance=0
  ro2: Impedance Faces=cavity.face(at (0, 16.25, 5)) Resistance=50 Reactance=0
  drive1: Impedance Faces=cavity.face(at (-18.75, -15, 15.4)) Resistance=50 Reactance=0
  drive2: Impedance Faces=cavity.face(at (-6.25, -15, 15.4)) Resistance=50 Reactance=0
  drive3: Impedance Faces=cavity.face(at (6.25, -15, 15.4)) Resistance=50 Reactance=0
  drive4: Impedance Faces=cavity.face(at (18.75, -15, 15.4)) Resistance=50 Reactance=0
  cryo_copper: Finite Conductivity Faces=cavity.face(at (6.25, -27.5, 0), at (-6.25, -27.5, 0), at (-18.75, -27.5, 0), at (0, 0, 10.4), at (-24.4142, -6.91421, 0), at (0, -7.5, 0), at (24.4142, -6.91421, 0), at (25, 0, 0), at (24.4142, 6.91421, 0), at (0, 7.5, 0), at (-24.4142, 6.91421, 0), at (-25, 0, 0)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) UseMaterial Material=cryo_copper IsInternal
setups:
  EM_Cavity: HfssEigen MinimumFrequency=5GHz NumModes=10 MaxDeltaFreq=0.05 ConvergeOnRealFreq=true MaximumPasses=20 MinimumPasses=2 MinimumConvergedPasses=2 PercentRefinement=30 BasisOrder=-1
source amplitudes:
  #-10:1..#-10:4, #-10:7..#-10:10: 0V_per_meter 0deg
  #-10:5: 1 0deg
  #-10:6: 0 0deg
field plots:
  MagE_mode1_XY: MagE_mode1_XY over a plane on EM_Cavity : LastAdaptive at Phase=0deg
  MagE_mode1_YZ: MagE_mode1_YZ over a plane on EM_Cavity : LastAdaptive at Phase=0deg
  MagE_mode2_XY: MagE_mode2_XY over a plane on EM_Cavity : LastAdaptive at Phase=0deg
  MagE_mode2_YZ: MagE_mode2_YZ over a plane on EM_Cavity : LastAdaptive at Phase=0deg
  MagE_mode5_XY: MagE_mode5_XY over a plane on EM_Cavity : LastAdaptive at Phase=0deg
  MagE_mode5_YZ: MagE_mode5_YZ over a plane on EM_Cavity : LastAdaptive at Phase=0deg
  MagE_mode6_XY: MagE_mode6_XY over a plane on EM_Cavity : LastAdaptive at Phase=0deg
  MagE_mode6_YZ: MagE_mode6_YZ over a plane on EM_Cavity : LastAdaptive at Phase=0deg
  Mag_E1: E Field in cavity on EM_Cavity : LastAdaptive at Phase=0deg

design EM_Cavity_with_Transmons (HFSS, Eigenmode, model units mm)
variables:
  Lj1 = 11nH
  Lj2 = 12nH
  Lj3 = 13nH
  Lj4 = 14nH
geometry:
  Solid1, Solid1_1 = imported_body(C:\Users\epm114\Documents\GitHub\Cavity work\coffin_4Q\inventor_files\coffin_4Q.stp)
  cavity [vacuum] = box(corner=(-31mm, -42.5mm, -15.4mm), size=(62mm, 58.75mm, 30.8mm))
  cavity.subtract(Solid1, Solid1_1)
  ro_pin_1 = cylinder(axis=Y, base_centre=($ro1_x, $y_front - $ro_pin_len, $ro1_z), radius=$pin_r, height=$ro_pin_len)
  ro_pin_2 = cylinder(axis=Y, base_centre=($ro2_x, $y_front - $ro_pin_len, $ro2_z), radius=$pin_r, height=$ro_pin_len)
  drive_pin_1 = cylinder(axis=Z, base_centre=($q1_x, -($cav_W/2 + $drive_dy), $block_H/2 - $drive_pin_len), radius=$pin_r, height=$drive_pin_len)
  drive_pin_2 = cylinder(axis=Z, base_centre=($q2_x, -($cav_W/2 + $drive_dy), $block_H/2 - $drive_pin_len), radius=$pin_r, height=$drive_pin_len)
  drive_pin_3 = cylinder(axis=Z, base_centre=($q3_x, -($cav_W/2 + $drive_dy), $block_H/2 - $drive_pin_len), radius=$pin_r, height=$drive_pin_len)
  drive_pin_4 = cylinder(axis=Z, base_centre=($q4_x, -($cav_W/2 + $drive_dy), $block_H/2 - $drive_pin_len), radius=$pin_r, height=$drive_pin_len)
  cavity.subtract(ro_pin_1, ro_pin_2, drive_pin_1..drive_pin_4)
  substrate_1 [sapphire] = box(corner=(-19.975mm, -23.13mm, -0.5mm), size=(2.45mm, 16.63mm, 0.43mm))
  pad_1a = rectangle(corner=(-18.85mm, -8.565mm, -0.07mm), x_size=0.2mm, y_size=2mm)
  lead_1a = rectangle(corner=(-18.765mm, -8.65mm, -0.07mm), x_size=0.03mm, y_size=0.085mm)
  pad_1b = rectangle(corner=(-18.85mm, -12.765mm, -0.07mm), x_size=0.2mm, y_size=4mm)
  lead_1b = rectangle(corner=(-18.765mm, -8.765mm, -0.07mm), x_size=0.03mm, y_size=0.085mm)
  pad_1a.unite(lead_1a)
  pad_1b.unite(lead_1b)
  jj_1 = rectangle(corner=(-18.765mm, -8.68mm, -0.07mm), x_size=0.03mm, y_size=0.03mm)
  jj_line_1 [non-model] = polyline((-18.75mm, -8.68mm, -0.07mm) (-18.75mm, -8.65mm, -0.07mm))
  substrate_2 [sapphire] = box(corner=(-7.475mm, -23.13mm, -0.5mm), size=(2.45mm, 16.63mm, 0.43mm))
  pad_2a = rectangle(corner=(-6.35mm, -8.565mm, -0.07mm), x_size=0.2mm, y_size=2mm)
  lead_2a = rectangle(corner=(-6.265mm, -8.65mm, -0.07mm), x_size=0.03mm, y_size=0.085mm)
  pad_2b = rectangle(corner=(-6.35mm, -12.765mm, -0.07mm), x_size=0.2mm, y_size=4mm)
  lead_2b = rectangle(corner=(-6.265mm, -8.765mm, -0.07mm), x_size=0.03mm, y_size=0.085mm)
  pad_2a.unite(lead_2a)
  pad_2b.unite(lead_2b)
  jj_2 = rectangle(corner=(-6.265mm, -8.68mm, -0.07mm), x_size=0.03mm, y_size=0.03mm)
  jj_line_2 [non-model] = polyline((-6.25mm, -8.68mm, -0.07mm) (-6.25mm, -8.65mm, -0.07mm))
  substrate_3 [sapphire] = box(corner=(5.025mm, -23.13mm, -0.5mm), size=(2.45mm, 16.63mm, 0.43mm))
  pad_3a = rectangle(corner=(6.15mm, -8.565mm, -0.07mm), x_size=0.2mm, y_size=2mm)
  lead_3a = rectangle(corner=(6.235mm, -8.65mm, -0.07mm), x_size=0.03mm, y_size=0.085mm)
  pad_3b = rectangle(corner=(6.15mm, -12.765mm, -0.07mm), x_size=0.2mm, y_size=4mm)
  lead_3b = rectangle(corner=(6.235mm, -8.765mm, -0.07mm), x_size=0.03mm, y_size=0.085mm)
  pad_3a.unite(lead_3a)
  pad_3b.unite(lead_3b)
  jj_3 = rectangle(corner=(6.235mm, -8.68mm, -0.07mm), x_size=0.03mm, y_size=0.03mm)
  jj_line_3 [non-model] = polyline((6.25mm, -8.68mm, -0.07mm) (6.25mm, -8.65mm, -0.07mm))
  substrate_4 [sapphire] = box(corner=(17.525mm, -23.13mm, -0.5mm), size=(2.45mm, 16.63mm, 0.43mm))
  pad_4a = rectangle(corner=(18.65mm, -8.565mm, -0.07mm), x_size=0.2mm, y_size=2mm)
  lead_4a = rectangle(corner=(18.735mm, -8.65mm, -0.07mm), x_size=0.03mm, y_size=0.085mm)
  pad_4b = rectangle(corner=(18.65mm, -12.765mm, -0.07mm), x_size=0.2mm, y_size=4mm)
  lead_4b = rectangle(corner=(18.735mm, -8.765mm, -0.07mm), x_size=0.03mm, y_size=0.085mm)
  pad_4a.unite(lead_4a)
  pad_4b.unite(lead_4b)
  jj_4 = rectangle(corner=(18.735mm, -8.68mm, -0.07mm), x_size=0.03mm, y_size=0.03mm)
  jj_line_4 [non-model] = polyline((18.75mm, -8.68mm, -0.07mm) (18.75mm, -8.65mm, -0.07mm))
boundaries and excitations:
  ro1: Impedance Faces=cavity.face(at (0, 16.25, -5)) Resistance=50 Reactance=0
  ro2: Impedance Faces=cavity.face(at (0, 16.25, 5)) Resistance=50 Reactance=0
  drive1: Impedance Faces=cavity.face(at (-18.75, -15, 15.4)) Resistance=50 Reactance=0
  drive2: Impedance Faces=cavity.face(at (-6.25, -15, 15.4)) Resistance=50 Reactance=0
  drive3: Impedance Faces=cavity.face(at (6.25, -15, 15.4)) Resistance=50 Reactance=0
  drive4: Impedance Faces=cavity.face(at (18.75, -15, 15.4)) Resistance=50 Reactance=0
  cryo_copper: Finite Conductivity Faces=cavity.face(at (6.25, -27.5, 0), at (-6.25, -27.5, 0), at (-18.75, -27.5, 0), at (0, 0, 10.4), at (-24.4142, -6.91421, 0), at (0, -7.5, 0), at (24.4142, -6.91421, 0), at (25, 0, 0), at (24.4142, 6.91421, 0), at (0, 7.5, 0), at (-24.4142, 6.91421, 0), at (-25, 0, 0)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) UseMaterial Material=cryo_copper IsInternal
  pads_1: Perfect E Objects=[pad_1a, pad_1b]
  jj1: Lumped RLC Objects=jj_1 CurrentLine{(-18.75, -8.68, -0.07) -> (-18.75, -8.65, -0.07)} RLC_Type=Parallel Inductance=Lj1
  pads_2: Perfect E Objects=[pad_2a, pad_2b]
  jj2: Lumped RLC Objects=jj_2 CurrentLine{(-6.25, -8.68, -0.07) -> (-6.25, -8.65, -0.07)} RLC_Type=Parallel Inductance=Lj2
  pads_3: Perfect E Objects=[pad_3a, pad_3b]
  jj3: Lumped RLC Objects=jj_3 CurrentLine{(6.25, -8.68, -0.07) -> (6.25, -8.65, -0.07)} RLC_Type=Parallel Inductance=Lj3
  pads_4: Perfect E Objects=[pad_4a, pad_4b]
  jj4: Lumped RLC Objects=jj_4 CurrentLine{(18.75, -8.68, -0.07) -> (18.75, -8.65, -0.07)} RLC_Type=Parallel Inductance=Lj4
mesh:
  tmon_substrate: LengthBased Objects=[substrate_1..substrate_4] MaxLength=0.5mm
  tmon_pads: LengthBased Objects=[pad_1a, pad_1b, pad_2a, pad_2b, pad_3a, pad_3b, pad_4a, pad_4b] MaxLength=50um
  tmon_jj: LengthBased Objects=[jj_1..jj_4] MaxLength=10um
setups:
  EM_Cavity_with_Transmons: HfssEigen MinimumFrequency=3GHz NumModes=12 MaxDeltaFreq=0.1 ConvergeOnRealFreq=true MaximumPasses=20 MinimumPasses=2 MinimumConvergedPasses=2 PercentRefinement=30 BasisOrder=-1
source amplitudes:
  #-10:1, #-10:3..#-10:12: 0 0
  #-10:2: 1 0
field plots:
  TM_MagE_mode3_XY: TM_MagE_mode3_XY over a plane on EM_Cavity_with_Transmons : LastAdaptive at Phase=0deg
  TM_MagE_mode4_XY: TM_MagE_mode4_XY over a plane on EM_Cavity_with_Transmons : LastAdaptive at Phase=0deg
  TM_MagE_mode12_XY: TM_MagE_mode12_XY over a plane on EM_Cavity_with_Transmons : LastAdaptive at Phase=0deg
  TM_MagE_mode1_XY: TM_MagE_mode1_XY over a plane on EM_Cavity_with_Transmons : LastAdaptive at Phase=0deg
  TM_MagE_mode2_XY: TM_MagE_mode2_XY over a plane on EM_Cavity_with_Transmons : LastAdaptive at Phase=0deg
reports:
  Eigen Modes Table 1: re(Mode(1)) vs Lj1 on EM_Cavity_with_Transmons : LastAdaptive
  Eigen Modes Plot 1: re(Mode(1)) vs Lj1 on EM_Cavity_with_Transmons : LastAdaptive
  Freq. vs. pass: re(Mode(1)), re(Mode(2)), re(Mode(3)), re(Mode(4)), re(Mode(5)), re(Mode(6)), re(Mode(7)), re(Mode(8)), re(Mode(9)), re(Mode(10)), re(Mode(11)), re(Mode(12)) vs Pass on EM_Cavity_with_Transmons : AdaptivePass [$block_H=30.8mm $block_L=62mm $cav_H=20.8mm $cav_L=50mm $cav_r=2mm $cav_W=15mm $chip_T=0.5mm $drive_dia=2.946mm $drive_dy=7.5mm $drive_pin_gap=2mm $ovl=0.5mm $pin_r=0.635mm $q1_x=-18.75mm $q2_x=-6.25mm $q3_x=6.25mm $q4_x=18.75mm $ro1_x=0mm $ro1_z=-5mm $ro2_x=0mm $ro2_z=5mm $ro_dia=2.946mm $ro_pin_len=5mm $ro_port_len=8.75mm $top_pocket_D=0.43mm $top_pocket_L=10mm $tunnel_L=30mm $tunnel_r=0mm $tunnel_W=6.5mm $wall_back=5mm $wall_x=6mm $wall_z=5mm $y_back=42.5mm $y_front=16.25mm Lj1=11nH Lj2=12nH Lj3=13nH Lj4=14nH]

design DM (HFSS, HFSS Modal Network, model units mm)
geometry:
  Solid1, Solid1_1 = imported_body(C:\Users\epm114\Documents\GitHub\Cavity work\coffin_4Q\inventor_files\coffin_4Q.stp)
  cavity [vacuum] = box(corner=(-31mm, -42.5mm, -15.4mm), size=(62mm, 58.75mm, 30.8mm))
  cavity.subtract(Solid1, Solid1_1)
  ro_pin_1 = cylinder(axis=Y, base_centre=($ro1_x, $y_front - $ro_pin_len, $ro1_z), radius=$pin_r, height=$ro_pin_len)
  ro_pin_2 = cylinder(axis=Y, base_centre=($ro2_x, $y_front - $ro_pin_len, $ro2_z), radius=$pin_r, height=$ro_pin_len)
  drive_pin_1 = cylinder(axis=Z, base_centre=($q1_x, -($cav_W/2 + $drive_dy), $block_H/2 - $drive_pin_len), radius=$pin_r, height=$drive_pin_len)
  drive_pin_2 = cylinder(axis=Z, base_centre=($q2_x, -($cav_W/2 + $drive_dy), $block_H/2 - $drive_pin_len), radius=$pin_r, height=$drive_pin_len)
  drive_pin_3 = cylinder(axis=Z, base_centre=($q3_x, -($cav_W/2 + $drive_dy), $block_H/2 - $drive_pin_len), radius=$pin_r, height=$drive_pin_len)
  drive_pin_4 = cylinder(axis=Z, base_centre=($q4_x, -($cav_W/2 + $drive_dy), $block_H/2 - $drive_pin_len), radius=$pin_r, height=$drive_pin_len)
  cavity.subtract(ro_pin_1, ro_pin_2, drive_pin_1..drive_pin_4)
  substrate_1 [sapphire] = box(corner=(-19.975mm, -23.63mm, -0.5mm), size=(2.45mm, 16.63mm, 0.43mm))
  pad_1a = rectangle(corner=(-18.85mm, -9.065mm, -0.07mm), x_size=0.2mm, y_size=2mm)
  lead_1a = rectangle(corner=(-18.765mm, -9.15mm, -0.07mm), x_size=0.03mm, y_size=0.085mm)
  pad_1b = rectangle(corner=(-18.85mm, -13.265mm, -0.07mm), x_size=0.2mm, y_size=4mm)
  lead_1b = rectangle(corner=(-18.765mm, -9.265mm, -0.07mm), x_size=0.03mm, y_size=0.085mm)
  pad_1a.unite(lead_1a)
  pad_1b.unite(lead_1b)
  jj_1 = rectangle(corner=(-18.765mm, -9.18mm, -0.07mm), x_size=0.03mm, y_size=0.03mm)
  jj_line_1 [non-model] = polyline((-18.75mm, -9.18mm, -0.07mm) (-18.75mm, -9.15mm, -0.07mm))
  substrate_2 [sapphire] = box(corner=(-7.475mm, -23.63mm, -0.5mm), size=(2.45mm, 16.63mm, 0.43mm))
  pad_2a = rectangle(corner=(-6.35mm, -9.065mm, -0.07mm), x_size=0.2mm, y_size=2mm)
  lead_2a = rectangle(corner=(-6.265mm, -9.15mm, -0.07mm), x_size=0.03mm, y_size=0.085mm)
  pad_2b = rectangle(corner=(-6.35mm, -13.265mm, -0.07mm), x_size=0.2mm, y_size=4mm)
  lead_2b = rectangle(corner=(-6.265mm, -9.265mm, -0.07mm), x_size=0.03mm, y_size=0.085mm)
  pad_2a.unite(lead_2a)
  pad_2b.unite(lead_2b)
  jj_2 = rectangle(corner=(-6.265mm, -9.18mm, -0.07mm), x_size=0.03mm, y_size=0.03mm)
  jj_line_2 [non-model] = polyline((-6.25mm, -9.18mm, -0.07mm) (-6.25mm, -9.15mm, -0.07mm))
  substrate_3 [sapphire] = box(corner=(5.025mm, -23.63mm, -0.5mm), size=(2.45mm, 16.63mm, 0.43mm))
  pad_3a = rectangle(corner=(6.15mm, -9.065mm, -0.07mm), x_size=0.2mm, y_size=2mm)
  lead_3a = rectangle(corner=(6.235mm, -9.15mm, -0.07mm), x_size=0.03mm, y_size=0.085mm)
  pad_3b = rectangle(corner=(6.15mm, -13.265mm, -0.07mm), x_size=0.2mm, y_size=4mm)
  lead_3b = rectangle(corner=(6.235mm, -9.265mm, -0.07mm), x_size=0.03mm, y_size=0.085mm)
  pad_3a.unite(lead_3a)
  pad_3b.unite(lead_3b)
  jj_3 = rectangle(corner=(6.235mm, -9.18mm, -0.07mm), x_size=0.03mm, y_size=0.03mm)
  jj_line_3 [non-model] = polyline((6.25mm, -9.18mm, -0.07mm) (6.25mm, -9.15mm, -0.07mm))
  substrate_4 [sapphire] = box(corner=(17.525mm, -23.63mm, -0.5mm), size=(2.45mm, 16.63mm, 0.43mm))
  pad_4a = rectangle(corner=(18.65mm, -9.065mm, -0.07mm), x_size=0.2mm, y_size=2mm)
  lead_4a = rectangle(corner=(18.735mm, -9.15mm, -0.07mm), x_size=0.03mm, y_size=0.085mm)
  pad_4b = rectangle(corner=(18.65mm, -13.265mm, -0.07mm), x_size=0.2mm, y_size=4mm)
  lead_4b = rectangle(corner=(18.735mm, -9.265mm, -0.07mm), x_size=0.03mm, y_size=0.085mm)
  pad_4a.unite(lead_4a)
  pad_4b.unite(lead_4b)
  jj_4 = rectangle(corner=(18.735mm, -9.18mm, -0.07mm), x_size=0.03mm, y_size=0.03mm)
  jj_line_4 [non-model] = polyline((18.75mm, -9.18mm, -0.07mm) (18.75mm, -9.15mm, -0.07mm))
boundaries and excitations:
  ro1: Impedance Faces=cavity.face(at (0, 16.25, -5)) Resistance=50 Reactance=0
  ro2: Impedance Faces=cavity.face(at (0, 16.25, 5)) Resistance=50 Reactance=0
  drive1: Impedance Faces=cavity.face(at (-18.75, -15, 15.4)) Resistance=50 Reactance=0
  drive2: Impedance Faces=cavity.face(at (-6.25, -15, 15.4)) Resistance=50 Reactance=0
  drive3: Impedance Faces=cavity.face(at (6.25, -15, 15.4)) Resistance=50 Reactance=0
  drive4: Impedance Faces=cavity.face(at (18.75, -15, 15.4)) Resistance=50 Reactance=0
  cryo_copper: Finite Conductivity Faces=cavity.face(at (6.25, -27.5, 0), at (-6.25, -27.5, 0), at (-18.75, -27.5, 0), at (0, 0, 10.4), at (-24.4142, -6.91421, 0), at (0, -7.5, 0), at (24.4142, -6.91421, 0), at (25, 0, 0), at (24.4142, 6.91421, 0), at (0, 7.5, 0), at (-24.4142, 6.91421, 0), at (-25, 0, 0)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) UseMaterial Material=cryo_copper IsInternal
  pads_1: Perfect E Objects=[pad_1a, pad_1b]
  pads_2: Perfect E Objects=[pad_2a, pad_2b]
  pads_3: Perfect E Objects=[pad_3a, pad_3b]
  pads_4: Perfect E Objects=[pad_4a, pad_4b]
  jj1: Lumped Port Objects=jj_1 LumpedPortType=Modal Modes{Mode1{IntLine{(-18.75, -9.18, -0.07) -> (-18.75, -9.15, -0.07)} CharImp=Zpi}} Impedance=1000000ohm
  jj2: Lumped Port Objects=jj_2 LumpedPortType=Modal Modes{Mode1{IntLine{(-6.25, -9.18, -0.07) -> (-6.25, -9.15, -0.07)} CharImp=Zpi}} Impedance=1000000ohm
  jj3: Lumped Port Objects=jj_3 LumpedPortType=Modal Modes{Mode1{IntLine{(6.25, -9.18, -0.07) -> (6.25, -9.15, -0.07)} CharImp=Zpi}} Impedance=1000000ohm
  jj4: Lumped Port Objects=jj_4 LumpedPortType=Modal Modes{Mode1{IntLine{(18.75, -9.18, -0.07) -> (18.75, -9.15, -0.07)} CharImp=Zpi}} Impedance=1000000ohm
mesh:
  tmon_substrate: LengthBased Objects=[substrate_1..substrate_4] MaxLength=0.5mm
  tmon_pads: LengthBased Objects=[pad_1a, pad_1b, pad_2a, pad_2b, pad_3a, pad_3b, pad_4a, pad_4b] MaxLength=50um
  tmon_jj: LengthBased Objects=[jj_1..jj_4] MaxLength=10um
setups:
  DM: HfssDriven Frequency=4GHz MaxDeltaS=0.01 MaximumPasses=10 MinimumPasses=3 MinimumConvergedPasses=3 PercentRefinement=30 BasisOrder=-1 PortAccuracy=2 DrivenSolverType="Direct Solver"
    sweep Sweep_000: 3GHz to 3.1GHz, 10000 points; Type=Fast
    sweep Sweep_001: 3.1GHz to 3.2GHz, 10000 points; Type=Fast
    sweep Sweep_002: 3.2GHz to 3.3GHz, 10000 points; Type=Fast
    sweep Sweep_003: 3.3GHz to 3.4GHz, 10000 points; Type=Fast
    sweep Sweep_004: 3.4GHz to 3.5GHz, 10000 points; Type=Fast
    sweep Sweep_005: 3.5GHz to 3.6GHz, 10000 points; Type=Fast
    sweep Sweep_006: 3.6GHz to 3.7GHz, 10000 points; Type=Fast
    sweep Sweep_007: 3.7GHz to 3.8GHz, 10000 points; Type=Fast
    sweep Sweep_008: 3.8GHz to 3.9GHz, 10000 points; Type=Fast
    sweep Sweep_009: 3.9GHz to 4GHz, 10000 points; Type=Fast
    sweep Sweep_010: 4GHz to 4.1GHz, 10000 points; Type=Fast
    sweep Sweep_011: 4.1GHz to 4.2GHz, 10000 points; Type=Fast
    sweep Sweep_012: 4.2GHz to 4.3GHz, 10000 points; Type=Fast
    sweep Sweep_013: 4.3GHz to 4.4GHz, 10000 points; Type=Fast
    sweep Sweep_014: 4.4GHz to 4.5GHz, 10000 points; Type=Fast
    sweep Sweep_015: 4.5GHz to 4.6GHz, 10000 points; Type=Fast
    sweep Sweep_016: 4.6GHz to 4.7GHz, 10000 points; Type=Fast
    sweep Sweep_017: 4.7GHz to 4.8GHz, 10000 points; Type=Fast
    sweep Sweep_018: 4.8GHz to 4.9GHz, 10000 points; Type=Fast
    sweep Sweep_019: 4.9GHz to 5GHz, 10000 points; Type=Fast
    sweep Sweep_020: 5GHz to 5.1GHz, 10000 points; Type=Fast
    sweep Sweep_021: 5.1GHz to 5.2GHz, 10000 points; Type=Fast
    sweep Sweep_022: 5.2GHz to 5.3GHz, 10000 points; Type=Fast
    sweep Sweep_023: 5.3GHz to 5.4GHz, 10000 points; Type=Fast
    sweep Sweep_024: 5.4GHz to 5.5GHz, 10000 points; Type=Fast
    sweep Sweep_025: 5.5GHz to 5.6GHz, 10000 points; Type=Fast
    sweep Sweep_026: 5.6GHz to 5.7GHz, 10000 points; Type=Fast
    sweep Sweep_027: 5.7GHz to 5.8GHz, 10000 points; Type=Fast
    sweep Sweep_028: 5.8GHz to 5.9GHz, 10000 points; Type=Fast
    sweep Sweep_029: 5.9GHz to 6GHz, 10000 points; Type=Fast
    sweep Sweep_030: 6GHz to 6.1GHz, 10000 points; Type=Fast
    sweep Sweep_031: 6.1GHz to 6.2GHz, 10000 points; Type=Fast
    sweep Sweep_032: 6.2GHz to 6.3GHz, 10000 points; Type=Fast
    sweep Sweep_033: 6.3GHz to 6.4GHz, 10000 points; Type=Fast
    sweep Sweep_034: 6.4GHz to 6.5GHz, 10000 points; Type=Fast
    sweep Sweep_035: 6.5GHz to 6.6GHz, 10000 points; Type=Fast
    sweep Sweep_036: 6.6GHz to 6.7GHz, 10000 points; Type=Fast
    sweep Sweep_037: 6.7GHz to 6.8GHz, 10000 points; Type=Fast
    sweep Sweep_038: 6.8GHz to 6.9GHz, 10000 points; Type=Fast
    sweep Sweep_039: 6.9GHz to 7GHz, 10000 points; Type=Fast
    sweep Sweep_040: 7GHz to 7.1GHz, 10000 points; Type=Fast
    sweep Sweep_041: 7.1GHz to 7.2GHz, 10000 points; Type=Fast
    sweep Sweep_042: 7.2GHz to 7.3GHz, 10000 points; Type=Fast
    sweep Sweep_043: 7.3GHz to 7.4GHz, 10000 points; Type=Fast
    sweep Sweep_044: 7.4GHz to 7.5GHz, 10000 points; Type=Fast
    sweep Sweep_045: 7.5GHz to 7.6GHz, 10000 points; Type=Fast
    sweep Sweep_046: 7.6GHz to 7.7GHz, 10000 points; Type=Fast
    sweep Sweep_047: 7.7GHz to 7.8GHz, 10000 points; Type=Fast
    sweep Sweep_048: 7.8GHz to 7.9GHz, 10000 points; Type=Fast
    sweep Sweep_049: 7.9GHz to 8GHz, 10000 points; Type=Fast
    sweep Sweep_050: 8GHz to 8.1GHz, 10000 points; Type=Fast
    sweep Sweep_051: 8.1GHz to 8.2GHz, 10000 points; Type=Fast
    sweep Sweep_052: 8.2GHz to 8.3GHz, 10000 points; Type=Fast
    sweep Sweep_053: 8.3GHz to 8.4GHz, 10000 points; Type=Fast
    sweep Sweep_054: 8.4GHz to 8.5GHz, 10000 points; Type=Fast
    sweep Sweep_055: 8.5GHz to 8.6GHz, 10000 points; Type=Fast
    sweep Sweep_056: 8.6GHz to 8.7GHz, 10000 points; Type=Fast
    sweep Sweep_057: 8.7GHz to 8.8GHz, 10000 points; Type=Fast
    sweep Sweep_058: 8.8GHz to 8.9GHz, 10000 points; Type=Fast
    sweep Sweep_059: 8.9GHz to 9GHz, 10000 points; Type=Fast
    sweep Sweep_060: 9GHz to 9.1GHz, 10000 points; Type=Fast
    sweep Sweep_061: 9.1GHz to 9.2GHz, 10000 points; Type=Fast
    sweep Sweep_062: 9.2GHz to 9.3GHz, 10000 points; Type=Fast
    sweep Sweep_063: 9.3GHz to 9.4GHz, 10000 points; Type=Fast
    sweep Sweep_064: 9.4GHz to 9.5GHz, 10000 points; Type=Fast
    sweep Sweep_065: 9.5GHz to 9.6GHz, 10000 points; Type=Fast
    sweep Sweep_066: 9.6GHz to 9.7GHz, 10000 points; Type=Fast
    sweep Sweep_067: 9.7GHz to 9.8GHz, 10000 points; Type=Fast
    sweep Sweep_068: 9.8GHz to 9.9GHz, 10000 points; Type=Fast
    sweep Sweep_069: 9.9GHz to 10GHz, 10000 points; Type=Fast
source amplitudes:
  jj1:1: 1W 0deg
  jj2:1, jj3:1, jj4:1: 0W 0deg

design DM_1port_Q1 (HFSS, HFSS Modal Network, model units mm)
variables:
  Lj2 = 12nH
  Lj3 = 13nH
  Lj4 = 14nH
geometry:
  Solid1, Solid1_1 = imported_body(C:\Users\epm114\Documents\GitHub\Cavity work\coffin_4Q\inventor_files\coffin_4Q.stp)
  cavity [vacuum] = box(corner=(-31mm, -42.5mm, -15.4mm), size=(62mm, 58.75mm, 30.8mm))
  cavity.subtract(Solid1, Solid1_1)
  ro_pin_1 = cylinder(axis=Y, base_centre=($ro1_x, $y_front - $ro_pin_len, $ro1_z), radius=$pin_r, height=$ro_pin_len)
  ro_pin_2 = cylinder(axis=Y, base_centre=($ro2_x, $y_front - $ro_pin_len, $ro2_z), radius=$pin_r, height=$ro_pin_len)
  drive_pin_1 = cylinder(axis=Z, base_centre=($q1_x, -($cav_W/2 + $drive_dy), $block_H/2 - $drive_pin_len), radius=$pin_r, height=$drive_pin_len)
  drive_pin_2 = cylinder(axis=Z, base_centre=($q2_x, -($cav_W/2 + $drive_dy), $block_H/2 - $drive_pin_len), radius=$pin_r, height=$drive_pin_len)
  drive_pin_3 = cylinder(axis=Z, base_centre=($q3_x, -($cav_W/2 + $drive_dy), $block_H/2 - $drive_pin_len), radius=$pin_r, height=$drive_pin_len)
  drive_pin_4 = cylinder(axis=Z, base_centre=($q4_x, -($cav_W/2 + $drive_dy), $block_H/2 - $drive_pin_len), radius=$pin_r, height=$drive_pin_len)
  cavity.subtract(ro_pin_1, ro_pin_2, drive_pin_1..drive_pin_4)
  substrate_1 [sapphire] = box(corner=(-19.975mm, -23.63mm, -0.5mm), size=(2.45mm, 16.63mm, 0.43mm))
  pad_1a = rectangle(corner=(-18.85mm, -9.065mm, -0.07mm), x_size=0.2mm, y_size=2mm)
  lead_1a = rectangle(corner=(-18.765mm, -9.15mm, -0.07mm), x_size=0.03mm, y_size=0.085mm)
  pad_1b = rectangle(corner=(-18.85mm, -13.265mm, -0.07mm), x_size=0.2mm, y_size=4mm)
  lead_1b = rectangle(corner=(-18.765mm, -9.265mm, -0.07mm), x_size=0.03mm, y_size=0.085mm)
  pad_1a.unite(lead_1a)
  pad_1b.unite(lead_1b)
  jj_1 = rectangle(corner=(-18.765mm, -9.18mm, -0.07mm), x_size=0.03mm, y_size=0.03mm)
  jj_line_1 [non-model] = polyline((-18.75mm, -9.18mm, -0.07mm) (-18.75mm, -9.15mm, -0.07mm))
  substrate_2 [sapphire] = box(corner=(-7.475mm, -23.63mm, -0.5mm), size=(2.45mm, 16.63mm, 0.43mm))
  pad_2a = rectangle(corner=(-6.35mm, -9.065mm, -0.07mm), x_size=0.2mm, y_size=2mm)
  lead_2a = rectangle(corner=(-6.265mm, -9.15mm, -0.07mm), x_size=0.03mm, y_size=0.085mm)
  pad_2b = rectangle(corner=(-6.35mm, -13.265mm, -0.07mm), x_size=0.2mm, y_size=4mm)
  lead_2b = rectangle(corner=(-6.265mm, -9.265mm, -0.07mm), x_size=0.03mm, y_size=0.085mm)
  pad_2a.unite(lead_2a)
  pad_2b.unite(lead_2b)
  jj_2 = rectangle(corner=(-6.265mm, -9.18mm, -0.07mm), x_size=0.03mm, y_size=0.03mm)
  jj_line_2 [non-model] = polyline((-6.25mm, -9.18mm, -0.07mm) (-6.25mm, -9.15mm, -0.07mm))
  substrate_3 [sapphire] = box(corner=(5.025mm, -23.63mm, -0.5mm), size=(2.45mm, 16.63mm, 0.43mm))
  pad_3a = rectangle(corner=(6.15mm, -9.065mm, -0.07mm), x_size=0.2mm, y_size=2mm)
  lead_3a = rectangle(corner=(6.235mm, -9.15mm, -0.07mm), x_size=0.03mm, y_size=0.085mm)
  pad_3b = rectangle(corner=(6.15mm, -13.265mm, -0.07mm), x_size=0.2mm, y_size=4mm)
  lead_3b = rectangle(corner=(6.235mm, -9.265mm, -0.07mm), x_size=0.03mm, y_size=0.085mm)
  pad_3a.unite(lead_3a)
  pad_3b.unite(lead_3b)
  jj_3 = rectangle(corner=(6.235mm, -9.18mm, -0.07mm), x_size=0.03mm, y_size=0.03mm)
  jj_line_3 [non-model] = polyline((6.25mm, -9.18mm, -0.07mm) (6.25mm, -9.15mm, -0.07mm))
  substrate_4 [sapphire] = box(corner=(17.525mm, -23.63mm, -0.5mm), size=(2.45mm, 16.63mm, 0.43mm))
  pad_4a = rectangle(corner=(18.65mm, -9.065mm, -0.07mm), x_size=0.2mm, y_size=2mm)
  lead_4a = rectangle(corner=(18.735mm, -9.15mm, -0.07mm), x_size=0.03mm, y_size=0.085mm)
  pad_4b = rectangle(corner=(18.65mm, -13.265mm, -0.07mm), x_size=0.2mm, y_size=4mm)
  lead_4b = rectangle(corner=(18.735mm, -9.265mm, -0.07mm), x_size=0.03mm, y_size=0.085mm)
  pad_4a.unite(lead_4a)
  pad_4b.unite(lead_4b)
  jj_4 = rectangle(corner=(18.735mm, -9.18mm, -0.07mm), x_size=0.03mm, y_size=0.03mm)
  jj_line_4 [non-model] = polyline((18.75mm, -9.18mm, -0.07mm) (18.75mm, -9.15mm, -0.07mm))
boundaries and excitations:
  ro1: Impedance Faces=cavity.face(at (0, 16.25, -5)) Resistance=50 Reactance=0
  ro2: Impedance Faces=cavity.face(at (0, 16.25, 5)) Resistance=50 Reactance=0
  drive1: Impedance Faces=cavity.face(at (-18.75, -15, 15.4)) Resistance=50 Reactance=0
  drive2: Impedance Faces=cavity.face(at (-6.25, -15, 15.4)) Resistance=50 Reactance=0
  drive3: Impedance Faces=cavity.face(at (6.25, -15, 15.4)) Resistance=50 Reactance=0
  drive4: Impedance Faces=cavity.face(at (18.75, -15, 15.4)) Resistance=50 Reactance=0
  cryo_copper: Finite Conductivity Faces=cavity.face(at (6.25, -27.5, 0), at (-6.25, -27.5, 0), at (-18.75, -27.5, 0), at (0, 0, 10.4), at (-24.4142, -6.91421, 0), at (0, -7.5, 0), at (24.4142, -6.91421, 0), at (25, 0, 0), at (24.4142, 6.91421, 0), at (0, 7.5, 0), at (-24.4142, 6.91421, 0), at (-25, 0, 0)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) UseMaterial Material=cryo_copper IsInternal
  pads_1: Perfect E Objects=[pad_1a, pad_1b]
  pads_2: Perfect E Objects=[pad_2a, pad_2b]
  jj2: Lumped RLC Objects=jj_2 CurrentLine{(-6.25, -9.18, -0.07) -> (-6.25, -9.15, -0.07)} RLC_Type=Parallel Inductance=Lj2
  pads_3: Perfect E Objects=[pad_3a, pad_3b]
  jj3: Lumped RLC Objects=jj_3 CurrentLine{(6.25, -9.18, -0.07) -> (6.25, -9.15, -0.07)} RLC_Type=Parallel Inductance=Lj3
  pads_4: Perfect E Objects=[pad_4a, pad_4b]
  jj4: Lumped RLC Objects=jj_4 CurrentLine{(18.75, -9.18, -0.07) -> (18.75, -9.15, -0.07)} RLC_Type=Parallel Inductance=Lj4
  jj1: Lumped Port Objects=jj_1 LumpedPortType=Modal Modes{Mode1{IntLine{(-18.75, -9.18, -0.07) -> (-18.75, -9.15, -0.07)} CharImp=Zpi}} Impedance=1000000ohm
mesh:
  tmon_substrate: LengthBased Objects=[substrate_1..substrate_4] MaxLength=0.5mm
  tmon_pads: LengthBased Objects=[pad_1a, pad_1b, pad_2a, pad_2b, pad_3a, pad_3b, pad_4a, pad_4b] MaxLength=50um
  tmon_jj: LengthBased Objects=[jj_1..jj_4] MaxLength=10um
setups:
  DM_1port: HfssDriven Frequency=7GHz MaxDeltaS=0.01 MaximumPasses=10 MinimumPasses=3 MinimumConvergedPasses=3 PercentRefinement=30 BasisOrder=-1 PortAccuracy=2 DrivenSolverType="Direct Solver"
    sweep Sweep_000_4UHTXL: 3GHz to 3.1GHz, 10000 points; Type=Fast
    sweep Sweep_001_CFHFI1: 3.1GHz to 3.2GHz, 10000 points; Type=Fast
    sweep Sweep_002_HCVRRV: 3.2GHz to 3.3GHz, 10000 points; Type=Fast
    sweep Sweep_003_J2P5BW: 3.3GHz to 3.4GHz, 10000 points; Type=Fast
    sweep Sweep_004_9TUROW: 3.4GHz to 3.5GHz, 10000 points; Type=Fast
    sweep Sweep_005_V04KFI: 3.5GHz to 3.6GHz, 10000 points; Type=Fast
    sweep Sweep_006_2G5VWI: 3.6GHz to 3.7GHz, 10000 points; Type=Fast
    sweep Sweep_007_WFZK5B: 3.7GHz to 3.8GHz, 10000 points; Type=Fast
    sweep Sweep_008_E8Y1EQ: 3.8GHz to 3.9GHz, 10000 points; Type=Fast
    sweep Sweep_009_9BI89R: 3.9GHz to 4GHz, 10000 points; Type=Fast
    sweep Sweep_010_90F8RI: 4GHz to 4.1GHz, 10000 points; Type=Fast
    sweep Sweep_011_YOW7WR: 4.1GHz to 4.2GHz, 10000 points; Type=Fast
    sweep Sweep_012_N5Z32H: 4.2GHz to 4.3GHz, 10000 points; Type=Fast
    sweep Sweep_013_N7M12E: 4.3GHz to 4.4GHz, 10000 points; Type=Fast
    sweep Sweep_014_TAHCOX: 4.4GHz to 4.5GHz, 10000 points; Type=Fast
    sweep Sweep_015_M3X3WS: 4.5GHz to 4.6GHz, 10000 points; Type=Fast
    sweep Sweep_016_WAA094: 4.6GHz to 4.7GHz, 10000 points; Type=Fast
    sweep Sweep_017_5517K5: 4.7GHz to 4.8GHz, 10000 points; Type=Fast
    sweep Sweep_018_T4FCF3: 4.8GHz to 4.9GHz, 10000 points; Type=Fast
    sweep Sweep_019_KOUO58: 4.9GHz to 5GHz, 10000 points; Type=Fast
    sweep Sweep_020_46AOKU: 5GHz to 5.1GHz, 10000 points; Type=Fast
    sweep Sweep_021_ELRB5Y: 5.1GHz to 5.2GHz, 10000 points; Type=Fast
    sweep Sweep_022_KCDO5T: 5.2GHz to 5.3GHz, 10000 points; Type=Fast
    sweep Sweep_023_L8Z551: 5.3GHz to 5.4GHz, 10000 points; Type=Fast
    sweep Sweep_024_GEIC4O: 5.4GHz to 5.5GHz, 10000 points; Type=Fast
    sweep Sweep_025_2U4Y4E: 5.5GHz to 5.6GHz, 10000 points; Type=Fast
    sweep Sweep_026_EQYGGV: 5.6GHz to 5.7GHz, 10000 points; Type=Fast
    sweep Sweep_027_UYL0E5: 5.7GHz to 5.8GHz, 10000 points; Type=Fast
    sweep Sweep_028_GNDN3J: 5.8GHz to 5.9GHz, 10000 points; Type=Fast
    sweep Sweep_029_I6CWHZ: 5.9GHz to 6GHz, 10000 points; Type=Fast
    sweep Sweep_030_M1X0Z7: 6GHz to 6.1GHz, 10000 points; Type=Fast
    sweep Sweep_031_RX2LD4: 6.1GHz to 6.2GHz, 10000 points; Type=Fast
    sweep Sweep_032_B1HZTE: 6.2GHz to 6.3GHz, 10000 points; Type=Fast
    sweep Sweep_033_YP0MPC: 6.3GHz to 6.4GHz, 10000 points; Type=Fast
    sweep Sweep_034_RXO0KN: 6.4GHz to 6.5GHz, 10000 points; Type=Fast
    sweep Sweep_035_COTKFK: 6.5GHz to 6.6GHz, 10000 points; Type=Fast
    sweep Sweep_036_4W7EAL: 6.6GHz to 6.7GHz, 10000 points; Type=Fast
    sweep Sweep_037_I5X2O4: 6.7GHz to 6.8GHz, 10000 points; Type=Fast
    sweep Sweep_038_9C6JR1: 6.8GHz to 6.9GHz, 10000 points; Type=Fast
    sweep Sweep_039_41PJE1: 6.9GHz to 7GHz, 10000 points; Type=Fast
    sweep Sweep_040_ET5FC8: 7GHz to 7.1GHz, 10000 points; Type=Fast
    sweep Sweep_041_KQ5QTP: 7.1GHz to 7.2GHz, 10000 points; Type=Fast
    sweep Sweep_042_8N0SJD: 7.2GHz to 7.3GHz, 10000 points; Type=Fast
    sweep Sweep_043_XJI713: 7.3GHz to 7.4GHz, 10000 points; Type=Fast
    sweep Sweep_044_OM36HN: 7.4GHz to 7.5GHz, 10000 points; Type=Fast
    sweep Sweep_045_95W209: 7.5GHz to 7.6GHz, 10000 points; Type=Fast
    sweep Sweep_046_7TKF77: 7.6GHz to 7.7GHz, 10000 points; Type=Fast
    sweep Sweep_047_DMWV6Y: 7.7GHz to 7.8GHz, 10000 points; Type=Fast
    sweep Sweep_048_PNVUDD: 7.8GHz to 7.9GHz, 10000 points; Type=Fast
    sweep Sweep_049_PGML2D: 7.9GHz to 8GHz, 10000 points; Type=Fast
    sweep Sweep_050_DXVR1F: 8GHz to 8.1GHz, 10000 points; Type=Fast
    sweep Sweep_051_H1B73F: 8.1GHz to 8.2GHz, 10000 points; Type=Fast
    sweep Sweep_052_QMB3LL: 8.2GHz to 8.3GHz, 10000 points; Type=Fast
    sweep Sweep_053_YG13X1: 8.3GHz to 8.4GHz, 10000 points; Type=Fast
    sweep Sweep_054_EU2SJL: 8.4GHz to 8.5GHz, 10000 points; Type=Fast
    sweep Sweep_055_5LPOQQ: 8.5GHz to 8.6GHz, 10000 points; Type=Fast
    sweep Sweep_056_Y9PII3: 8.6GHz to 8.7GHz, 10000 points; Type=Fast
    sweep Sweep_057_CNY0V3: 8.7GHz to 8.8GHz, 10000 points; Type=Fast
    sweep Sweep_058_5VKXWV: 8.8GHz to 8.9GHz, 10000 points; Type=Fast
    sweep Sweep_059_MAN2SO: 8.9GHz to 9GHz, 10000 points; Type=Fast
    sweep Sweep_060_CYSF47: 9GHz to 9.1GHz, 10000 points; Type=Fast
    sweep Sweep_061_FNP0KM: 9.1GHz to 9.2GHz, 10000 points; Type=Fast
    sweep Sweep_062_E1Q52G: 9.2GHz to 9.3GHz, 10000 points; Type=Fast
    sweep Sweep_063_NFBDI0: 9.3GHz to 9.4GHz, 10000 points; Type=Fast
    sweep Sweep_064_9TEI87: 9.4GHz to 9.5GHz, 10000 points; Type=Fast
    sweep Sweep_065_YOO5L8: 9.5GHz to 9.6GHz, 10000 points; Type=Fast
    sweep Sweep_066_7W1W3J: 9.6GHz to 9.7GHz, 10000 points; Type=Fast
    sweep Sweep_067_OSZ4H5: 9.7GHz to 9.8GHz, 10000 points; Type=Fast
    sweep Sweep_068_FVZ2R1: 9.8GHz to 9.9GHz, 10000 points; Type=Fast
    sweep Sweep_069_2PJQXY: 9.9GHz to 10GHz, 10000 points; Type=Fast
source amplitudes:
  jj1:1: 1W 0deg
